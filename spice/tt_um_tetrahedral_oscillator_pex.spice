* NGSPICE file created from tt_um_tetrahedral_oscillator.ext - technology: sky130A

.subckt sky130_fd_sc_hd__inv_1 VNB VPB VGND VPWR A Y
X0 Y A VGND VNB sky130_fd_pr__nfet_01v8 ad=0.169 pd=1.82 as=0.169 ps=1.82 w=0.65 l=0.15
X1 Y A VPWR VPB sky130_fd_pr__pfet_01v8_hvt ad=0.26 pd=2.52 as=0.26 ps=2.52 w=1 l=0.15
.ends

.subckt sky130_fd_sc_hd__inv_2 VNB VPB VPWR VGND Y A
X0 Y A VPWR VPB sky130_fd_pr__pfet_01v8_hvt ad=0.135 pd=1.27 as=0.26 ps=2.52 w=1 l=0.15
X1 VGND A Y VNB sky130_fd_pr__nfet_01v8 ad=0.169 pd=1.82 as=0.08775 ps=0.92 w=0.65 l=0.15
X2 Y A VGND VNB sky130_fd_pr__nfet_01v8 ad=0.08775 pd=0.92 as=0.169 ps=1.82 w=0.65 l=0.15
X3 VPWR A Y VPB sky130_fd_pr__pfet_01v8_hvt ad=0.26 pd=2.52 as=0.135 ps=1.27 w=1 l=0.15
.ends

.subckt sky130_fd_sc_hd__inv_4 A VGND VNB VPB VPWR Y
X0 Y A VPWR VPB sky130_fd_pr__pfet_01v8_hvt ad=0.135 pd=1.27 as=0.26 ps=2.52 w=1 l=0.15
X1 VGND A Y VNB sky130_fd_pr__nfet_01v8 ad=0.08775 pd=0.92 as=0.08775 ps=0.92 w=0.65 l=0.15
X2 VGND A Y VNB sky130_fd_pr__nfet_01v8 ad=0.169 pd=1.82 as=0.08775 ps=0.92 w=0.65 l=0.15
X3 VPWR A Y VPB sky130_fd_pr__pfet_01v8_hvt ad=0.26 pd=2.52 as=0.135 ps=1.27 w=1 l=0.15
X4 Y A VGND VNB sky130_fd_pr__nfet_01v8 ad=0.08775 pd=0.92 as=0.08775 ps=0.92 w=0.65 l=0.15
X5 Y A VPWR VPB sky130_fd_pr__pfet_01v8_hvt ad=0.135 pd=1.27 as=0.135 ps=1.27 w=1 l=0.15
X6 VPWR A Y VPB sky130_fd_pr__pfet_01v8_hvt ad=0.135 pd=1.27 as=0.135 ps=1.27 w=1 l=0.15
X7 Y A VGND VNB sky130_fd_pr__nfet_01v8 ad=0.08775 pd=0.92 as=0.169 ps=1.82 w=0.65 l=0.15
.ends

.subckt sky130_fd_pr__cap_mim_m3_1_XTS2C5 m3_n3186_n3040# c1_n3146_n3000# VSUBS
X0 c1_n3146_n3000# m3_n3186_n3040# sky130_fd_pr__cap_mim_m3_1 l=30 w=30
C0 c1_n3146_n3000# m3_n3186_n3040# 78.9944f
C1 c1_n3146_n3000# VSUBS 3.12051f
C2 m3_n3186_n3040# VSUBS 18.2382f
.ends

.subckt sky130_fd_sc_hd__buf_16 A VGND VNB VPB VPWR X a_109_47#
X0 VGND A a_109_47# VNB sky130_fd_pr__nfet_01v8 ad=0.08775 pd=0.92 as=0.08775 ps=0.92 w=0.65 l=0.15
X1 X a_109_47# VPWR VPB sky130_fd_pr__pfet_01v8_hvt ad=0.135 pd=1.27 as=0.135 ps=1.27 w=1 l=0.15
X2 VGND a_109_47# X VNB sky130_fd_pr__nfet_01v8 ad=0.08775 pd=0.92 as=0.08775 ps=0.92 w=0.65 l=0.15
X3 VGND a_109_47# X VNB sky130_fd_pr__nfet_01v8 ad=0.08775 pd=0.92 as=0.08775 ps=0.92 w=0.65 l=0.15
X4 X a_109_47# VPWR VPB sky130_fd_pr__pfet_01v8_hvt ad=0.135 pd=1.27 as=0.135 ps=1.27 w=1 l=0.15
X5 VGND a_109_47# X VNB sky130_fd_pr__nfet_01v8 ad=0.08775 pd=0.92 as=0.08775 ps=0.92 w=0.65 l=0.15
X6 VPWR a_109_47# X VPB sky130_fd_pr__pfet_01v8_hvt ad=0.135 pd=1.27 as=0.135 ps=1.27 w=1 l=0.15
X7 a_109_47# A VPWR VPB sky130_fd_pr__pfet_01v8_hvt ad=0.135 pd=1.27 as=0.135 ps=1.27 w=1 l=0.15
X8 X a_109_47# VPWR VPB sky130_fd_pr__pfet_01v8_hvt ad=0.135 pd=1.27 as=0.135 ps=1.27 w=1 l=0.15
X9 VPWR A a_109_47# VPB sky130_fd_pr__pfet_01v8_hvt ad=0.135 pd=1.27 as=0.135 ps=1.27 w=1 l=0.15
X10 X a_109_47# VGND VNB sky130_fd_pr__nfet_01v8 ad=0.08775 pd=0.92 as=0.08775 ps=0.92 w=0.65 l=0.15
X11 X a_109_47# VGND VNB sky130_fd_pr__nfet_01v8 ad=0.08775 pd=0.92 as=0.08775 ps=0.92 w=0.65 l=0.15
X12 X a_109_47# VGND VNB sky130_fd_pr__nfet_01v8 ad=0.08775 pd=0.92 as=0.08775 ps=0.92 w=0.65 l=0.15
X13 X a_109_47# VGND VNB sky130_fd_pr__nfet_01v8 ad=0.08775 pd=0.92 as=0.08775 ps=0.92 w=0.65 l=0.15
X14 a_109_47# A VPWR VPB sky130_fd_pr__pfet_01v8_hvt ad=0.135 pd=1.27 as=0.135 ps=1.27 w=1 l=0.15
X15 VPWR a_109_47# X VPB sky130_fd_pr__pfet_01v8_hvt ad=0.135 pd=1.27 as=0.135 ps=1.27 w=1 l=0.15
X16 X a_109_47# VGND VNB sky130_fd_pr__nfet_01v8 ad=0.08775 pd=0.92 as=0.08775 ps=0.92 w=0.65 l=0.15
X17 X a_109_47# VPWR VPB sky130_fd_pr__pfet_01v8_hvt ad=0.135 pd=1.27 as=0.135 ps=1.27 w=1 l=0.15
X18 VPWR A a_109_47# VPB sky130_fd_pr__pfet_01v8_hvt ad=0.135 pd=1.27 as=0.135 ps=1.27 w=1 l=0.15
X19 VPWR a_109_47# X VPB sky130_fd_pr__pfet_01v8_hvt ad=0.135 pd=1.27 as=0.135 ps=1.27 w=1 l=0.15
X20 VGND A a_109_47# VNB sky130_fd_pr__nfet_01v8 ad=0.08775 pd=0.92 as=0.08775 ps=0.92 w=0.65 l=0.15
X21 VGND A a_109_47# VNB sky130_fd_pr__nfet_01v8 ad=0.08775 pd=0.92 as=0.08775 ps=0.92 w=0.65 l=0.15
X22 VGND a_109_47# X VNB sky130_fd_pr__nfet_01v8 ad=0.08775 pd=0.92 as=0.08775 ps=0.92 w=0.65 l=0.15
X23 X a_109_47# VPWR VPB sky130_fd_pr__pfet_01v8_hvt ad=0.135 pd=1.27 as=0.135 ps=1.27 w=1 l=0.15
X24 VGND a_109_47# X VNB sky130_fd_pr__nfet_01v8 ad=0.08775 pd=0.92 as=0.08775 ps=0.92 w=0.65 l=0.15
X25 VPWR a_109_47# X VPB sky130_fd_pr__pfet_01v8_hvt ad=0.135 pd=1.27 as=0.135 ps=1.27 w=1 l=0.15
X26 VGND a_109_47# X VNB sky130_fd_pr__nfet_01v8 ad=0.08775 pd=0.92 as=0.08775 ps=0.92 w=0.65 l=0.15
X27 VPWR a_109_47# X VPB sky130_fd_pr__pfet_01v8_hvt ad=0.135 pd=1.27 as=0.135 ps=1.27 w=1 l=0.15
X28 X a_109_47# VPWR VPB sky130_fd_pr__pfet_01v8_hvt ad=0.135 pd=1.27 as=0.135 ps=1.27 w=1 l=0.15
X29 VGND a_109_47# X VNB sky130_fd_pr__nfet_01v8 ad=0.169 pd=1.82 as=0.08775 ps=0.92 w=0.65 l=0.15
X30 a_109_47# A VGND VNB sky130_fd_pr__nfet_01v8 ad=0.08775 pd=0.92 as=0.08775 ps=0.92 w=0.65 l=0.15
X31 a_109_47# A VGND VNB sky130_fd_pr__nfet_01v8 ad=0.08775 pd=0.92 as=0.08775 ps=0.92 w=0.65 l=0.15
X32 X a_109_47# VPWR VPB sky130_fd_pr__pfet_01v8_hvt ad=0.135 pd=1.27 as=0.135 ps=1.27 w=1 l=0.15
X33 VPWR a_109_47# X VPB sky130_fd_pr__pfet_01v8_hvt ad=0.135 pd=1.27 as=0.135 ps=1.27 w=1 l=0.15
X34 X a_109_47# VGND VNB sky130_fd_pr__nfet_01v8 ad=0.08775 pd=0.92 as=0.08775 ps=0.92 w=0.65 l=0.15
X35 X a_109_47# VGND VNB sky130_fd_pr__nfet_01v8 ad=0.08775 pd=0.92 as=0.08775 ps=0.92 w=0.65 l=0.15
X36 VPWR A a_109_47# VPB sky130_fd_pr__pfet_01v8_hvt ad=0.135 pd=1.27 as=0.135 ps=1.27 w=1 l=0.15
X37 X a_109_47# VPWR VPB sky130_fd_pr__pfet_01v8_hvt ad=0.135 pd=1.27 as=0.135 ps=1.27 w=1 l=0.15
X38 X a_109_47# VGND VNB sky130_fd_pr__nfet_01v8 ad=0.08775 pd=0.92 as=0.08775 ps=0.92 w=0.65 l=0.15
X39 a_109_47# A VPWR VPB sky130_fd_pr__pfet_01v8_hvt ad=0.135 pd=1.27 as=0.26 ps=2.52 w=1 l=0.15
X40 VPWR a_109_47# X VPB sky130_fd_pr__pfet_01v8_hvt ad=0.135 pd=1.27 as=0.135 ps=1.27 w=1 l=0.15
X41 VPWR a_109_47# X VPB sky130_fd_pr__pfet_01v8_hvt ad=0.26 pd=2.52 as=0.135 ps=1.27 w=1 l=0.15
X42 a_109_47# A VGND VNB sky130_fd_pr__nfet_01v8 ad=0.08775 pd=0.92 as=0.169 ps=1.82 w=0.65 l=0.15
X43 VGND a_109_47# X VNB sky130_fd_pr__nfet_01v8 ad=0.08775 pd=0.92 as=0.08775 ps=0.92 w=0.65 l=0.15
.ends

.subckt oscilador_base VDPWR m3_n3682_n5412# m3_n3682_3100# m3_n3794_n7204# m3_n3794_n11684#
+ m3_n3906_n1716# m3_n3906_n1380# m3_n3906_14188# m3_n3906_n9108# m3_n3794_n19076#
+ m3_n3682_11276# m3_n3682_636# m3_n3794_6012# m3_n3794_13068# m3_n3906_14412# m3_n3794_n12468#
+ m3_n3794_n19300# m3_n3682_n13588# m3_n3906_n2164# m3_n3682_11500# m3_n3906_20908#
+ m3_n3794_n1044# m3_n3906_20572# m3_n3682_n13812# m3_n3682_8924# m3_n3682_1980# m3_n3906_6684#
+ m3_n3906_21356# m3_n3794_n13140# m3_n3682_9372# m3_n3682_9708# m3_n3906_n7988# m3_n3682_n14260#
+ m3_n3794_20236# m3_n3682_n260# m3_n3906_n17732# m3_n3682_2764# m3_n3794_4892# m3_n3906_7468#
+ m3_n3794_18780# m3_n3794_n6868# m3_n3682_n15044# m3_n3682_17772# m3_n3906_n18516#
+ m3_n3682_3548# m3_n3794_5676# m3_n3794_19564# m3_n3794_n18964# m3_n3906_n18180#
+ m3_n3906_n8660# m3_n3906_n11572# m3_n3906_n11908# m3_n3794_5900# m3_n3794_12956#
+ m3_n3906_8140# m3_n3682_18556# m3_n3794_n7540# m3_n3794_n19748# m3_n3682_11948#
+ m3_n3906_n9444# m3_n3906_1532# m3_n3682_n6532# m3_n3906_n12356# m3_n3682_972# m3_n3682_4220#
+ m3_n3794_n8324# m3_n3906_n2836# m3_n3906_2316# m3_n3682_12396# m3_n3682_n7316# m3_n3794_n1716#
+ m3_n3794_14188# m3_n3794_n13588# m3_n3794_n1380# m3_n3682_5004# m3_n3794_7132# m3_n3906_15532#
+ m3_n3794_n9108# m3_n3906_n3284# m3_n3682_12620# m3_n3794_14412# m3_n3794_n13812#
+ m3_n3906_21692# m3_n3682_n14932# m3_n3794_n2164# m3_n3906_16316# m3_n3906_n4068#
+ m3_n3682_n932# m3_n3682_13404# m3_n3794_20908# m3_n3794_1308# m3_n3794_20572# m3_n3682_n1156#
+ m3_n3906_22476# m3_n3794_n14260# m3_n3682_n15716# m3_n3682_n15380# m3_n3794_21356#
+ m3_n3906_22700# m3_n3906_n18852# m3_n3906_10156# m3_n3794_n15044# m3_n3682_3884#
+ m3_n3906_8588# m3_n3794_n7988# m3_n3682_n16164# m3_n3682_20348# m3_n3906_8812# m3_n3682_18892#
+ m3_n3906_n19636# m3_n3682_4668# m3_n3794_6796# m3_n3906_n9780# m3_n3906_n12692#
+ m3_n3682_19676# m3_n3906_9260# m3_n3794_n8660# m3_n3682_21020# m3_n3682_19900# m3_n3906_n13476#
+ m3_n3906_2652# m3_n3794_7804# m3_n3682_n7652# m3_n3682_5340# m3_n3794_n9444# m3_n3906_n3956#
+ m3_n3906_n13700# m3_n3794_n2836# m3_n3906_3436# m3_n3682_n8436# m3_n3682_n11012#
+ m3_n3682_6124# m3_n3794_8252# m3_n3906_16652# m3_n3682_13740# m3_n3682_n1828# m3_n3682_n1492#
+ m3_n3794_1644# m3_n3794_15532# m3_n3794_n14932# m3_n3794_n3284# m3_n3794_9036# m3_n3906_17436#
+ m3_n3906_n5188# m3_n3682_14524# m3_n3794_21692# m3_n3794_2428# m3_n3906_10828# m3_n3794_16316#
+ m3_n3794_n15716# m3_n3682_n2276# m3_n3794_2092# m3_n3906_10492# m3_n3794_n15380#
+ m3_n3682_n16836# m3_n3906_n5412# m3_n3794_n4068# m3_n3682_20684# m3_n3682_15308#
+ m3_n3682_n2500# m3_n3794_22476# m3_n3906_n19972# m3_n3906_11276# m3_n3794_n16164#
+ m3_n3682_n17284# m3_n3906_n596# m3_n3682_21468# m3_n3794_22700# m3_n3794_3100# m3_n3906_9932#
+ m3_n3794_10156# m3_n3906_11500# m3_n3682_5788# m3_n3682_n10676# m3_n3906_n820# m3_n3682_n18068#
+ m3_n3682_n10900# m3_n3794_n9780# m3_n3906_524# m3_n3682_22140# m3_n3906_3772# m3_n3682_n8772#
+ m3_n3906_n14596# m3_n3682_6460# m3_n3794_8924# m3_n3906_n14820# m3_n3794_1980# m3_n3906_4556#
+ m3_n3682_n9556# m3_n3794_n11012# m3_n3794_n3956# m3_n3794_9708# m3_n3682_n12132#
+ m3_n3682_7244# m3_n3794_9372# m3_n3906_17772# m3_n3794_n260# m3_n3682_14860# m3_n3906_n15604#
+ m3_n3682_n2948# m3_n3794_2764# m3_n3794_16652# m3_n3682_8028# m3_n3906_18556# m3_n3682_15644#
+ m3_n3794_3548# m3_n3906_11948# m3_n3906_n16052# m3_n3682_n3396# m3_n3682_1084# m3_n3794_17436#
+ m3_n3906_n6532# m3_n3794_n16836# m3_n3682_n17956# m3_n3794_n5188# m3_n3794_10828#
+ m3_n3682_n3620# m3_n3794_10492# m3_n3682_16092# m3_n3682_16428# m3_n3794_n5412#
+ m3_n3906_6012# m3_n3906_12396# m3_n3906_n7316# m3_n3794_n17284# m3_n3682_22588#
+ m3_n3906_n10228# m3_n3682_n4404# m3_n3794_4220# m3_n3794_11276# m3_n3906_12620#
+ semilogo_0/m4_0_0# m3_n3794_n10676# m3_n3682_n11796# m3_n3682_22812# m3_n3794_n18068#
+ m3_n3906_860# m3_n3682_10268# m3_n3794_11500# m3_n3794_n10900# m3_n3682_n19188#
+ m3_n3682_17100# m3_n3794_5004# m3_n3906_13404# m3_n3906_n1156# m3_n3682_n19412#
+ m3_n3682_n12804# m3_n3794_524# m3_n3906_4892# m3_n3682_7916# m3_n3682_n9892# m3_n3794_n932#
+ m3_n3682_7580# m3_n3906_n15940# m3_n3682_300# m3_n3906_20348# m3_n3794_n12132# m3_n3906_5676#
+ m3_n3682_n13252# m3_n3682_8364# m3_n3906_18892# m3_n3906_5900# m3_n3682_15980# m3_n3906_n16724#
+ m3_n3682_1756# m3_n3794_3884# m3_n3794_17772# m3_n3682_9148# m3_n3906_19676# m3_n3682_n14036#
+ m3_n3682_16764# m3_n3906_21020# m3_n3906_n17172# m3_n3906_n17508# m3_n3794_4668#
+ m3_n3794_18556# m3_n3906_19900# m3_n3794_n17956# m3_n3906_n7652# m3_n3906_n10564#
+ m3_n3794_11948# m3_n3682_17548# m3_n3682_n4740# m3_n3906_7132# m3_n3794_n6532# m3_n3906_n8436#
+ m3_n3906_n11348# m3_n3682_n5524# m3_n3682_3212# m3_n3794_5340# m3_n3794_12396# m3_n3906_13740#
+ m3_n3794_n7316# m3_n3794_n11796# m3_n3906_n1828# m3_n3794_n19188# m3_n3906_n1492#
+ m3_n3906_1308# m3_n3682_11388# m3_n3794_12620# m3_n3682_18220# m3_n3682_n6308# m3_n3682_748#
+ m3_n3794_6124# m3_n3906_14524# m3_n3794_n19412# m3_n3794_860# m3_n3906_n2276# m3_n3682_11612#
+ m3_n3906_n12020# m3_n3794_13404# m3_n3682_19004# m3_n3794_n12804# m3_n3906_15308#
+ m3_n3906_20684# m3_n3682_n13924# m3_n3906_n2500# m3_n3794_n1156# m3_n3682_12060#
+ m3_n3906_6796# m3_n3906_21468# m3_n3794_n13252# m3_n3682_n14708# m3_n3682_n14372#
+ m3_n3682_n708# m3_n3682_9484# m3_n3682_n372# m3_n3794_20348# m3_n3906_n17844# m3_n3682_2876#
+ m3_n3794_18892# m3_n3794_n14036# m3_n3682_n15156# m3_n3682_17884# m3_n3906_n18628#
+ m3_n3794_5788# m3_n3906_7804# m3_n3906_22140# m3_n3906_n18292# m3_n3794_19676# m3_n3906_n8772#
+ m3_n3794_21020# m3_n3906_n11684# m3_n3682_n5860# m3_n3682_18668# m3_n3794_19900#
+ m3_n3794_n7652# m3_n3906_n19076# m3_n3906_8252# m3_n3682_20012# m3_n3906_n9556#
+ m3_n3906_1644# m3_n3682_n6644# m3_n3906_n12468# m3_n3906_n19300# m3_n3682_4332#
+ m3_n3794_6460# m3_n3906_14860# m3_n3794_n8436# m3_n3906_n2948# m3_n3906_9036# m3_n3906_2428#
+ m3_n3794_13740# m3_n3794_n1828# m3_n3906_2092# m3_n3682_19340# m3_n3682_n7092# m3_n3682_n7428#
+ m3_n3682_n10004# m3_n3794_n1492# m3_n3682_5116# m3_n3794_7244# m3_n3906_15644# m3_n3906_n3396#
+ m3_n3682_12732# m3_n3794_14524# m3_n3906_n13140# m3_n3794_n13924# m3_n3906_n3620#
+ m3_n3794_n2276# m3_n3794_8028# m3_n3906_16428# m3_n3906_16092# m3_n3906_3100# m3_n3682_13180#
+ m3_n3682_13516# m3_n3794_20684# m3_n3794_n2500# m3_n3682_n1268# m3_n3794_1084# m3_n3794_15308#
+ m3_n3906_22588# m3_n3682_n8100# m3_n3794_n14372# m3_n3794_n14708# m3_n3682_n15492#
+ m3_n3682_n15828# m3_n3906_n4404# m3_n3794_21468# m3_n3906_22812# m3_n3906_10268#
+ m3_n3906_n18964# m3_n3682_3996# m3_n3906_17100# m3_n3794_n15156# m3_n3682_n16276#
+ m3_n3906_8924# m3_n3906_n19748# m3_n3682_n16500# m3_n3906_n9892# m3_n3906_1980#
+ m3_n3794_22140# m3_n3906_9708# m3_n3682_19788# m3_n3682_n6980# m3_n3906_9372# m3_n3794_n8772#
+ m3_n3906_n260# m3_n3682_21132# m3_n3906_n13588# m3_n3906_2764# m3_n3794_7916# m3_n3682_n7764#
+ m3_n3682_n10340# m3_n3682_5452# m3_n3794_7580# m3_n3906_15980# m3_n3794_n9556# m3_n3906_n13812#
+ m3_n3794_n10004# m3_n3906_3548# m3_n3794_14860# m3_n3682_n8548# m3_n3682_n11124#
+ m3_n3794_n2948# m3_n3682_6236# m3_n3794_8364# m3_n3906_16764# m3_n3906_76# m3_n3682_13852#
+ m3_n3906_n14260# m3_n3794_1756# m3_n3794_15644# m3_n3794_9148# m3_n3906_17548# m3_n3906_n4740#
+ m3_n3794_n3396# m3_n3682_14636# m3_n3906_4220# m3_n3794_16428# m3_n3682_n9220# m3_n3906_n15044#
+ m3_n3794_n15828# m3_n3794_n3620# m3_n3682_n2388# m3_n3794_16092# m3_n3794_n15492#
+ m3_n3682_n16948# m3_n3906_n5524# m3_n3682_20796# m3_n3682_n2612# m3_n3906_5004#
+ m3_n3682_15084# m3_n3794_22588# m3_n3794_n4404# m3_n3906_11388# m3_n3906_18220#
+ m3_n3794_n16276# m3_n3906_n6308# m3_n3682_n17396# m3_n3906_n36# m3_n3794_22812#
+ m3_n3794_3212# m3_n3794_10268# m3_n3906_11612# m3_n3794_17100# m3_n3794_n16500#
+ m3_n3682_n3060# m3_n3682_n10788# m3_n3682_n17620# m3_n3906_n932# m3_n3906_19004#
+ m3_n3682_21804# m3_n3906_12060# m3_n3794_n9892# m3_n3682_n18404# m3_n3906_636# m3_n3682_22252#
+ m3_n3906_3884# m3_n3682_n8884# m3_n3794_n10340# m3_n3682_6572# m3_n3682_6908# m3_n3682_n11460#
+ m3_n3906_n14932# m3_n3906_4668# m3_n3794_15980# m3_n3794_n11124# m3_n3682_n9668#
+ m3_n3682_n12244# m3_n3794_n708# m3_n3682_7356# m3_n3794_9484# m3_n3906_17884# m3_n3794_n372#
+ m3_n3682_14972# m3_n3906_n15716# m3_n3794_2876# m3_n3794_16764# m3_n3906_n15380#
+ m3_n3682_n13028# m3_n3906_n5860# m3_n3906_18668# m3_n3906_5340# m3_n3682_15756#
+ m3_n3906_20012# m3_n3906_n16164# m3_n3794_n4740# m3_n3682_1196# m3_n3794_17548#
+ m3_n3794_n16948# m3_n3906_n6644# m3_n3682_n3732# m3_n3682_1420# m3_n3794_n5524#
+ m3_n3906_6124# m3_n3906_19340# m3_n3906_n7428# m3_n3794_n17396# m3_n3906_n7092#
+ m3_n3682_n4516# m3_n3794_11388# m3_n3794_n10788# m3_n3682_n4180# m3_n3682_2204#
+ m3_n3794_4332# m3_n3906_12732# m3_n3794_18220# m3_n3794_n17620# m3_n3794_n6308#
+ m3_n3794_n36# m3_n3682_22924# m3_n3682_n18740# m3_n3906_972# m3_n3794_11612# m3_n3682_17212#
+ m3_n3794_5116# m3_n3906_13180# m3_n3906_13516# m3_n3794_19004# m3_n3794_n18404#
+ m3_n3906_n1268# m3_n3794_76# m3_n3682_10604# m3_n3906_n8100# m3_n3682_n19524# m3_n3906_n11012#
+ m3_n3794_12060# m3_n3794_n11460# m3_n3682_n12916# m3_n3682_188# m3_n3682_n12580#
+ m3_n3794_636# m3_n3682_7692# m3_n3682_11052# m3_n3682_412# m3_n3794_n12244# m3_n3906_5788#
+ m3_n3682_n13364# m3_n3682_8476# m3_n3906_n16836# m3_n3682_1868# m3_n3794_3996# m3_n3682_8700#
+ m3_n3794_17884# m3_n3794_n13028# m3_n3906_19788# m3_n3906_n6980# m3_n3682_n14148#
+ m3_n3682_n148# m3_n3682_16876# m3_n3906_21132# m3_n3906_6460# m3_n3794_18668# m3_n3906_n17284#
+ m3_n3794_n5860# m3_n3906_n7764# m3_n3794_20012# m3_n3906_n10676# m3_n3682_n4852#
+ m3_n3682_2540# m3_n3906_7244# m3_n3794_n6644# m3_n3906_n18068# m3_n3906_n8548# m3_n3906_n10900#
+ m3_n3682_76# m3_n3682_n5636# m3_n3682_3324# m3_n3794_5452# m3_n3906_8028# m3_n3906_13852#
+ m3_n3794_19340# m3_n3794_n7428# m3_n3794_n18740# m3_n3794_n7092# m3_n3682_n19860#
+ m3_n3682_10940# m3_n3794_12732# m3_n3682_18332# m3_n3906_1084# m3_n3682_4108# m3_n3794_6236#
+ m3_n3906_14636# m3_n3794_n19524# m3_n3682_n6084# m3_n3794_972# m3_n3906_n9220# m3_n3906_n2388#
+ m3_n3682_11724# m3_n3906_n12132# m3_n3794_13516# m3_n3682_19116# m3_n3794_n12916#
+ m3_n3794_13180# m3_n3906_20796# m3_n3794_n8100# m3_n3794_n12580# m3_n3906_n2612#
+ m3_n3794_n1268# m3_n3906_15084# m3_n3682_12508# m3_n3682_12172# m3_n3794_n13364#
+ m3_n3682_n14484# m3_n3906_n3060# m3_n3682_9596# m3_n3682_n484# m3_n3906_21804# m3_n3906_n17956#
+ m3_n3682_2988# m3_n3794_n14148# m3_n3682_9820# m3_n3682_n15268# m3_n3906_7580# m3_n3906_7916#
+ m3_n3682_17996# m3_n3906_22252# m3_n3794_n6980# m3_n3794_19788# m3_n3906_n8884#
+ m3_n3794_21132# m3_n3906_n11796# m3_n3682_n5972# m3_n3682_3660# m3_n3794_n7764#
+ m3_n3906_n19188# m3_n3906_8364# m3_n3682_20124# m3_n3906_n9668# m3_n3906_1756# m3_n3682_n6756#
+ m3_n3906_n19412# m3_n3794_6908# m3_n3682_4444# m3_n3794_6572# m3_n3906_9148# m3_n3906_14972#
+ m3_n3794_n8548# m3_n3794_n19860# m3_n3906_n12804# m3_n3794_13852# m3_n3682_19452#
+ m3_n3682_n10116# m3_n3682_5228# m3_n3794_7356# m3_n3906_15756# m3_n3682_12844# m3_n3906_n13252#
+ m3_n3794_14636# m3_n3906_n3732# m3_n3794_n2388# m3_n3794_n9220# m3_n3682_13292#
+ m3_n3682_13628# m3_n3794_20796# m3_n3906_n14036# m3_n3794_n2612# m3_n3794_1196#
+ m3_n3906_3212# m3_n3794_15084# m3_n3682_n8212# m3_n3794_n14484# m3_n3906_n4516#
+ m3_n3906_n4180# m3_n3682_n1604# m3_n3794_1420# m3_n3682_14076# m3_n3906_22924# m3_n3794_n3060#
+ m3_n3906_17212# m3_n3794_n15268# m3_n3794_21804# m3_n3682_n16388# m3_n3682_14300#
+ m3_n3682_n2052# m3_n3794_2204# m3_n3906_10604# m3_n3682_n16612# m3_n3682_20460#
+ m3_n3794_22252# m3_n3682_4780# m3_n3906_9484# m3_n3906_11052# m3_n3794_n8884# m3_n3906_n708#
+ m3_n3906_n372# m3_n3682_21244# m3_n3682_n17060# m3_n3906_2876# m3_n3682_n7876# m3_n3682_n10452#
+ m3_n3682_5564# m3_n3794_7692# m3_n3794_n9668# m3_n3682_22028# m3_n3906_n13924# m3_n3794_14972#
+ m3_n3794_n10116# m3_n3682_6348# m3_n3794_8476# m3_n3906_16876# m3_n3682_n11236#
+ m3_n3906_300# m3_n3682_13964# m3_n3906_n14372# m3_n3906_n14708# m3_n3794_1868# m3_n3794_8700#
+ m3_n3794_15756# m3_n3906_n4852# m3_n3794_n148# m3_n3682_14748# m3_n3682_n1940# m3_n3906_4332#
+ m3_n3682_n9332# m3_n3906_n15156# m3_n3794_n3732# m3_n3682_7020# m3_n3906_n5636#
+ m3_n3682_n2724# m3_n3794_2540# m3_n3906_5116# m3_n3906_10940# m3_n3682_15196# m3_n3794_n4516#
+ m3_n3794_n16388# m3_n3794_n4180# m3_n3906_18332# m3_n3906_n6084# m3_n3682_15420#
+ m3_n3794_22924# m3_n3682_n3508# m3_n3794_3324# m3_n3906_11724# m3_n3794_17212# m3_n3794_n16612#
+ m3_n3682_n3172# m3_n3682_n17732# m3_n3906_19116# m3_n3682_21916# m3_n3794_10604#
+ m3_n3682_16204# m3_n3682_21580# m3_n3794_4108# m3_n3906_12508# m3_n3906_12172# m3_n3794_n17060#
+ m3_n3682_n18516# m3_n3682_n18180# m3_n3906_748# m3_n3682_22364# m3_n3906_n10004#
+ m3_n3906_3996# m3_n3794_11052# m3_n3794_n10452# m3_n3682_n11908# m3_n3682_n8996#
+ m3_n3682_n11572# m3_n3682_6684# m3_n3682_10044# m3_n3794_n11236# m3_n3682_n12356#
+ m3_n3386_n6343# m3_n3682_7468# m3_n3794_9596# m3_n3906_17996# m3_n3794_n484# m3_n3906_n15828#
+ x16/X m3_n3794_2988# m3_n3906_n15492# m3_n3794_300# m3_n3794_9820# m3_n3794_16876#
+ m3_n3906_n5972# m3_n3682_15868# m3_n3906_20124# m3_n3906_n16276# m3_n3794_n4852#
+ m3_n3906_5452# m3_n3682_8140# m3_n3906_n6756# m3_n3906_n16500# m3_n3682_n3844# m3_n3682_1532#
+ m3_n3794_3660# m3_n3794_n5636# m3_n3906_6236# m3_n3906_19452# m3_n3794_10940# m3_n3682_16540#
+ m3_n3682_n4628# m3_n3682_n4292# m3_n3682_2316# m3_n3794_4444# m3_n3906_12844# m3_n3794_18332#
+ m3_n3794_n17732# m3_n3794_n6084# m3_n3682_n18852# m3_n3794_11724# m3_n3906_n10340#
+ m3_n3682_17324# m3_n3794_5228# m3_n3906_13628# m3_n3794_19116# m3_n3794_n18516#
+ m3_n3682_n5076# m3_n3906_13292# m3_n3906_n8212# m3_n3682_n19636# m3_n3794_n18180#
+ m3_n3682_10380# m3_n3682_10716# m3_n3906_n11124# m3_n3794_12172# m3_n3794_12508#
+ m3_n3682_18108# m3_n3794_n11572# m3_n3794_n11908# m3_n3682_n5300# m3_n3682_n12692#
+ m3_n3906_n1604# m3_n3794_748# m3_n3906_14076# m3_n3682_11164# m3_n3682_524# m3_n3906_14300#
+ m3_n3794_n12356# m3_n3682_8588# m3_n3682_n13476# m3_n3906_n2052# m3_n3906_20460#
+ m3_n3906_n16948# m3_n3682_8812# m3_n3794_17996# m3_n3682_n13700# m3_n3906_6908#
+ m3_n3682_16988# m3_n3906_6572# m3_n3906_21244# m3_n3906_n17396# m3_n3794_n5972#
+ m3_n3682_9260# m3_n3906_n7876# m3_n3794_20124# m3_n3906_n10788# m3_n3906_n17620#
+ m3_n3682_n4964# m3_n3682_2652# m3_n3794_4780# m3_n3906_7356# m3_n3906_22028# m3_n3794_n6756#
+ m3_n3682_17660# m3_n3906_n18404# m3_n3682_n5748# m3_n3682_3436# m3_n3794_5564# m3_n3906_13964#
+ m3_n3794_19452# m3_n3794_n18852# m3_n3682_n19972# m3_n3906_n11460# m3_n3794_12844#
+ m3_n3682_18444# m3_n3906_1196# m3_n3794_6348# m3_n3906_14748# m3_n3682_n6196# m3_n3906_n1940#
+ m3_n3906_n9332# m3_n3794_n19636# m3_n3682_11836# m3_n3906_1420# m3_n3794_13628#
+ m3_n3906_n12244# m3_n3682_n6420# m3_n3682_860# m3_n3794_13292# m3_n3682_19228# m3_n3794_n8212#
+ m3_n3794_n12692# m3_n3906_n2724# m3_n3906_15196# x13/X m3_n3906_2204# m3_n3682_12284#
+ m3_n3682_n7204# m3_n3906_n13028# m3_n3794_n1604# m3_n3794_7020# m3_n3794_14076#
+ m3_n3906_15420# m3_n3794_n13476# m3_n3906_n3508# m3_n3682_n14596# m3_n3906_n3172#
+ m3_n3682_n596# m3_n3682_13068# m3_n3794_14300# m3_n3906_21916# m3_n3794_n13700#
+ m3_n3906_21580# m3_n3682_n14820# m3_n3794_n2052# m3_n3682_9932# m3_n3906_16204#
+ m3_n3682_n820# m3_n3794_20460# m3_n3682_n1044# m3_n3906_22364# m3_n3682_n15604#
+ m3_n3906_7692# m3_n3906_n8996# m3_n3794_21244# m3_n3906_n18740# m3_n3682_3772# m3_n3906_10044#
+ m3_n3906_8476# m3_n3794_n7876# m3_n3682_n16052# m3_n3682_20236# m3_n3906_1868# m3_n3794_22028#
+ m3_n3906_n19524# m3_n3906_8700# m3_n3682_18780# m3_n3682_n6868# m3_n3682_4556# m3_n3794_6684#
+ m3_n3794_n19972# m3_n3906_n148# m3_n3906_n12916# m3_n3794_13964# m3_n3906_n12580#
+ m3_n3682_19564# m3_n3682_n10228# m3_n3794_7468# m3_n3906_15868# m3_n3906_2540# m3_n3682_12956#
+ m3_n3906_n13364# m3_n3794_n1940# m3_n3794_14748# m3_n3682_n7540# m3_n3794_n9332#
+ m3_n3906_n3844# m3_n3906_n14148# m3_n3794_n2724# m3_n3906_3324# m3_n3682_n8324#
+ m3_n3682_6012# m3_n3794_8140# m3_n3794_15196# m3_n3906_16540# m3_n3794_n14596# m3_n3906_n4628#
+ m3_n3906_n4292# m3_n3682_n1716# m3_n3682_n1380# m3_n3794_1532# m3_n3906_4108# m3_n3682_14188#
+ m3_n3794_15420# m3_n3682_n9108# m3_n3794_n14820# m3_n3794_n3508# m3_n3794_n3172#
+ m3_n3906_17324# m3_n3682_n15940# m3_n3794_21916# m3_n3906_n5076# m3_n3682_14412#
+ m3_n3794_21580# m3_n3682_n2164# m3_n3794_2316# m3_n3906_10380# m3_n3906_10716# m3_n3794_16204#
+ m3_n3794_n15604# m3_n3906_18108# m3_n3682_n16724# m3_n3906_n5300# m3_n3682_20572#
+ m3_n3682_20908# m3_n3794_22364# m3_n3906_n19860# m3_n3682_4892# m3_n3906_9596# m3_n3906_11164#
+ m3_n3794_n8996# m3_n3794_n16052# m3_n3682_n17508# m3_n3682_21356# m3_n3682_n17172#
+ m3_n3906_n484# m3_n3794_10044# x15/X m3_n3906_2988# m3_n3906_9820# m3_n3682_n7988#
+ m3_n3682_n10564# m3_n3682_5676# m3_n3906_188# m3_n3682_5900# m3_n3794_n10228# m3_n3794_8588#
+ m3_n3906_16988# m3_n3682_n11348# m3_n3906_412# m3_n3906_3660# m3_n3794_8812# m3_n3794_15868#
+ m3_n3682_n8660# m3_n3906_n14484# m3_n3906_n4964# m3_n3906_4444# m3_n3682_n9444#
+ m3_n3906_n15268# m3_n3794_n3844# m3_n3682_7132# m3_n3794_9260# m3_n3906_17660# m3_n3682_n12020#
+ m3_n3906_n5748# m3_n3682_n2836# m3_n3794_2652# m3_n3906_5228# m3_n3794_16540# m3_n3794_n15940#
+ m3_n3794_n4628# m3_n3794_n4292# m3_n3906_18444# m3_n3906_n6196# m3_n3682_15532#
+ m3_n3682_1308# m3_n3794_3436# m3_n3906_11836# m3_n3794_17324# m3_n3794_n16724# m3_n3682_n3284#
+ m3_n3682_n17844# m3_n3906_n6420# m3_n3794_n5076# m3_n3906_19228# m3_n3794_10716#
+ m3_n3682_21692# m3_n3794_10380# m3_n3682_16316# m3_n3794_n5300# m3_n3682_n4068#
+ m3_n3906_12284# m3_n3794_18108# m3_n3794_n17172# m3_n3794_n17508# m3_n3906_n7204#
+ m3_n3682_n18628# m3_n3682_n18292# m3_n3682_22476# m3_n3906_n10116# m3_n3794_11164#
+ m3_n3794_n10564# m3_n3906_13068# m3_n3682_n11684# m3_n3682_6796# m3_n3682_22700#
+ x9/A m3_n3682_10156# m3_n3682_n19076# m3_n3794_n11348# m3_n3682_n12468# m3_n3906_n1044#
+ m3_n3794_188# m3_n3682_n19300# m3_n3794_n596# m3_n3906_4780# m3_n3794_412# m3_n3682_7804#
+ m3_n3794_9932# m3_n3794_16988# m3_n3682_n9780# m3_n3794_n820# m3_n3906_20236# m3_n3794_n12020#
+ m3_n3906_n16388# m3_n3794_n4964# m3_n3906_5564# m3_n3682_n13140# m3_n3682_8252#
+ m3_n3906_18780# m3_n3906_n6868# m3_n3906_n16612# m3_n3682_n3956# m3_n3682_1644#
+ m3_n3794_3772# m3_n3906_6348# m3_n3794_17660# x14/X m3_n3794_n5748# m3_n3682_9036#
+ m3_n3906_19564# m3_n3682_16652# m3_n3906_n17060# m3_n3682_2428# m3_n3794_4556# m3_n3906_12956#
+ m3_n3794_18444# m3_n3794_n17844# m3_n3682_2092# m3_n3906_n7540# m3_n3682_n18964#
+ m3_n3794_n6196# VSUBS m3_n3906_n10452# m3_n3794_11836# m3_n3682_17436# m3_n3682_n36#
+ m3_n3906_7020# m3_n3794_19228# m3_n3794_n18628# m3_n3794_n6420# m3_n3682_n5188#
+ m3_n3906_n8324# m3_n3682_n19748# m3_n3794_n18292# m3_n3682_10492# m3_n3682_10828#
+ m3_n3906_n11236# m3_n3794_12284#
Xx1 VSUBS VDPWR VSUBS VDPWR x9/Y x4/A sky130_fd_sc_hd__inv_1
Xx2 VSUBS VDPWR VDPWR VSUBS x4/A x9/Y sky130_fd_sc_hd__inv_2
Xx3 VSUBS VDPWR VDPWR VSUBS x9/Y x4/A sky130_fd_sc_hd__inv_2
Xx4 VSUBS VDPWR VSUBS VDPWR x4/A x9/Y sky130_fd_sc_hd__inv_1
Xx5 VSUBS VDPWR VSUBS VDPWR x9/A x8/A sky130_fd_sc_hd__inv_1
Xx6 VSUBS VDPWR VDPWR VSUBS x8/A x9/A sky130_fd_sc_hd__inv_2
Xx7 VSUBS VDPWR VDPWR VSUBS x9/A x8/A sky130_fd_sc_hd__inv_2
Xx8 VSUBS VDPWR VSUBS VDPWR x8/A x9/A sky130_fd_sc_hd__inv_1
Xx9 x9/A VSUBS VSUBS VDPWR VDPWR x9/Y sky130_fd_sc_hd__inv_4
XXC10 m3_n3386_n6343# x9/Y VSUBS sky130_fd_pr__cap_mim_m3_1_XTS2C5
XXC11 m3_n3386_n6343# x9/A VSUBS sky130_fd_pr__cap_mim_m3_1_XTS2C5
XXC12 m3_n3386_n6343# x9/A VSUBS sky130_fd_pr__cap_mim_m3_1_XTS2C5
XXC13 m3_n3386_n6343# x9/A VSUBS sky130_fd_pr__cap_mim_m3_1_XTS2C5
XXC14 m3_n3386_n6343# x8/A VSUBS sky130_fd_pr__cap_mim_m3_1_XTS2C5
XXC15 m3_n3386_n6343# x8/A VSUBS sky130_fd_pr__cap_mim_m3_1_XTS2C5
XXC16 m3_n3386_n6343# x8/A VSUBS sky130_fd_pr__cap_mim_m3_1_XTS2C5
XXC1 m3_n3386_n6343# x4/A VSUBS sky130_fd_pr__cap_mim_m3_1_XTS2C5
XXC2 m3_n3386_n6343# x9/Y VSUBS sky130_fd_pr__cap_mim_m3_1_XTS2C5
Xx10 x9/Y VSUBS VSUBS VDPWR VDPWR x8/A sky130_fd_sc_hd__inv_4
XXC3 m3_n3386_n6343# x9/A VSUBS sky130_fd_pr__cap_mim_m3_1_XTS2C5
Xx11 x8/A VSUBS VSUBS VDPWR VDPWR x4/A sky130_fd_sc_hd__inv_4
XXC4 m3_n3386_n6343# x8/A VSUBS sky130_fd_pr__cap_mim_m3_1_XTS2C5
Xx12 x4/A VSUBS VSUBS VDPWR VDPWR x9/A sky130_fd_sc_hd__inv_4
XXC5 m3_n3386_n6343# x4/A VSUBS sky130_fd_pr__cap_mim_m3_1_XTS2C5
Xx13 x9/Y VSUBS VSUBS VDPWR VDPWR x13/X x13/a_109_47# sky130_fd_sc_hd__buf_16
XXC6 m3_n3386_n6343# x4/A VSUBS sky130_fd_pr__cap_mim_m3_1_XTS2C5
XXC7 m3_n3386_n6343# x4/A VSUBS sky130_fd_pr__cap_mim_m3_1_XTS2C5
Xx14 x9/A VSUBS VSUBS VDPWR VDPWR x14/X x14/a_109_47# sky130_fd_sc_hd__buf_16
Xx15 x4/A VSUBS VSUBS VDPWR VDPWR x15/X x15/a_109_47# sky130_fd_sc_hd__buf_16
XXC8 m3_n3386_n6343# x9/Y VSUBS sky130_fd_pr__cap_mim_m3_1_XTS2C5
Xx16 x8/A VSUBS VSUBS VDPWR VDPWR x16/X x16/a_109_47# sky130_fd_sc_hd__buf_16
XXC9 m3_n3386_n6343# x9/Y VSUBS sky130_fd_pr__cap_mim_m3_1_XTS2C5
C0 m3_n3906_n14036# m3_n3794_n14036# 0.06144f
C1 m3_n3906_14524# m3_n3906_14636# 0.06144f
C2 m3_n3682_n3396# m3_n3386_n6343# 0.0178f
C3 m3_n3682_14636# m3_n3794_14636# 0.06144f
C4 m3_n3682_n13924# m3_n3682_n14036# 0.06144f
C5 m3_n3794_4220# m3_n3794_4108# 0.06144f
C6 m3_n3682_n19636# m3_n3682_n19524# 0.06144f
C7 m3_n3794_3100# m3_n3794_3212# 0.06144f
C8 m3_n3794_n2612# m3_n3794_n2500# 0.06144f
C9 m3_n3794_n260# m3_n3794_n148# 0.06144f
C10 m3_n3906_n6756# m3_n3794_n6756# 0.06144f
C11 m3_n3794_n2724# m3_n3682_n2724# 0.06144f
C12 m3_n3906_n2724# m3_n3906_n2836# 0.06144f
C13 m3_n3682_n148# m3_n3682_n260# 0.06144f
C14 m3_n3794_n15604# m3_n3794_n15716# 0.06144f
C15 m3_n3794_n17844# m3_n3682_n17844# 0.06144f
C16 m3_n3906_1756# m3_n3794_1756# 0.06144f
C17 m3_n3906_16540# m3_n3906_16428# 0.06144f
C18 m3_n3794_n7988# m3_n3682_n7988# 0.06144f
C19 m3_n3386_n6343# m3_n3682_5452# 0.0178f
C20 m3_n3794_n11572# m3_n3906_n11572# 0.06144f
C21 m3_n3794_21468# m3_n3682_21468# 0.06144f
C22 m3_n3682_n11572# m3_n3682_n11460# 0.06144f
C23 m3_n3682_1756# m3_n3386_n6343# 0.0178f
C24 m3_n3906_n19972# m3_n3906_n19860# 0.06144f
C25 m3_n3682_n17172# m3_n3682_n17060# 0.06144f
C26 m3_n3794_18108# m3_n3682_18108# 0.06144f
C27 m3_n3682_n8324# m3_n3794_n8324# 0.06144f
C28 m3_n3906_n8436# m3_n3906_n8324# 0.06144f
C29 m3_n3906_n7204# m3_n3794_n7204# 0.06144f
C30 m3_n3682_3212# m3_n3682_3324# 0.06144f
C31 m3_n3794_3212# m3_n3906_3212# 0.06144f
C32 m3_n3906_n4964# m3_n3906_n5076# 0.06144f
C33 m3_n3794_n4964# m3_n3682_n4964# 0.06144f
C34 m3_n3794_7132# m3_n3794_7244# 0.06144f
C35 m3_n3794_n932# m3_n3794_n820# 0.06144f
C36 m3_n3794_4332# m3_n3794_4444# 0.06144f
C37 m3_n3682_15644# m3_n3682_15532# 0.06144f
C38 m3_n3794_22364# m3_n3682_22364# 0.06144f
C39 m3_n3794_n10228# m3_n3682_n10228# 0.06144f
C40 m3_n3906_16204# m3_n3794_16204# 0.06144f
C41 m3_n3906_18668# m3_n3906_18780# 0.06144f
C42 m3_n3906_16316# m3_n3794_16316# 0.06144f
C43 m3_n3794_n484# m3_n3794_n596# 0.06144f
C44 m3_n3682_972# m3_n3682_860# 0.06144f
C45 m3_n3682_16428# m3_n3682_16316# 0.06144f
C46 m3_n3682_5340# m3_n3682_5452# 0.06144f
C47 m3_n3794_7804# m3_n3906_7804# 0.06144f
C48 m3_n3682_12508# m3_n3682_12396# 0.06144f
C49 m3_n3794_13404# m3_n3682_13404# 0.06144f
C50 m3_n3682_7804# m3_n3682_7916# 0.06144f
C51 m3_n3682_n4628# m3_n3386_n6343# 0.0178f
C52 m3_n3794_n19748# m3_n3794_n19636# 0.06144f
C53 m3_n3794_7580# m3_n3682_7580# 0.06144f
C54 m3_n3682_n5748# m3_n3386_n6343# 0.0178f
C55 m3_n3794_n14708# m3_n3682_n14708# 0.06144f
C56 m3_n3906_15756# m3_n3906_15644# 0.06144f
C57 m3_n3794_15756# m3_n3682_15756# 0.06144f
C58 m3_n3794_n14372# m3_n3794_n14260# 0.06144f
C59 m3_n3794_20012# m3_n3794_19900# 0.06144f
C60 m3_n3794_n13476# m3_n3794_n13364# 0.06144f
C61 m3_n3906_n11572# m3_n3906_n11684# 0.06144f
C62 m3_n3794_n4068# m3_n3794_n3956# 0.06144f
C63 m3_n3794_n7988# m3_n3794_n7876# 0.06144f
C64 m3_n3906_n260# m3_n3906_n148# 0.06144f
C65 m3_n3682_n16164# m3_n3682_n16052# 0.06144f
C66 m3_n3906_18892# m3_n3906_18780# 0.06144f
C67 m3_n3794_18892# m3_n3682_18892# 0.06144f
C68 x16/a_109_47# x8/A 0.00855f
C69 m3_n3682_n372# m3_n3386_n6343# 0.0178f
C70 m3_n3906_524# m3_n3906_636# 0.06144f
C71 m3_n3682_636# m3_n3794_636# 0.06144f
C72 m3_n3906_19116# m3_n3794_19116# 0.06144f
C73 m3_n3794_9484# m3_n3794_9596# 0.06144f
C74 m3_n3682_n12020# m3_n3682_n12132# 0.06144f
C75 m3_n3906_n5076# m3_n3794_n5076# 0.06144f
C76 m3_n3682_n4964# m3_n3682_n5076# 0.06144f
C77 m3_n3906_22028# m3_n3906_21916# 0.06144f
C78 m3_n3794_22028# m3_n3682_22028# 0.06144f
C79 m3_n3906_n15716# m3_n3794_n15716# 0.06144f
C80 m3_n3794_11500# m3_n3794_11388# 0.06144f
C81 m3_n3794_16092# m3_n3794_16204# 0.06144f
C82 m3_n3906_n8772# m3_n3794_n8772# 0.06144f
C83 m3_n3682_n1268# m3_n3386_n6343# 0.0178f
C84 m3_n3794_n16724# m3_n3794_n16836# 0.06144f
C85 m3_n3794_19116# m3_n3682_19116# 0.06144f
C86 m3_n3906_19116# m3_n3906_19004# 0.06144f
C87 m3_n3682_n11348# m3_n3682_n11460# 0.06144f
C88 m3_n3682_n3508# m3_n3682_n3620# 0.06144f
C89 m3_n3794_n9668# m3_n3682_n9668# 0.06144f
C90 m3_n3906_n9668# m3_n3906_n9780# 0.06144f
C91 m3_n3906_1980# m3_n3794_1980# 0.06144f
C92 m3_n3682_n18180# m3_n3682_n18068# 0.06144f
C93 m3_n3794_12284# m3_n3682_12284# 0.06144f
C94 m3_n3794_17660# m3_n3794_17548# 0.06144f
C95 m3_n3906_n6756# m3_n3906_n6644# 0.06144f
C96 m3_n3682_n15492# m3_n3682_n15604# 0.06144f
C97 m3_n3906_n15604# m3_n3794_n15604# 0.06144f
C98 m3_n3682_n17396# m3_n3682_n17508# 0.06144f
C99 m3_n3906_n7876# m3_n3794_n7876# 0.06144f
C100 m3_n3906_5788# m3_n3794_5788# 0.06144f
C101 m3_n3682_12844# m3_n3682_12956# 0.06144f
C102 x13/X x13/a_109_47# 0.03609f
C103 m3_n3682_n8324# m3_n3682_n8436# 0.06144f
C104 m3_n3794_7356# m3_n3794_7468# 0.06144f
C105 m3_n3906_n708# m3_n3794_n708# 0.06144f
C106 m3_n3906_n8436# m3_n3794_n8436# 0.06144f
C107 m3_n3794_3772# m3_n3794_3660# 0.06144f
C108 m3_n3794_n7540# m3_n3794_n7652# 0.06144f
C109 m3_n3906_n13364# m3_n3906_n13476# 0.06144f
C110 m3_n3906_19564# m3_n3794_19564# 0.06144f
C111 m3_n3906_n6084# m3_n3794_n6084# 0.06144f
C112 m3_n3794_13404# m3_n3906_13404# 0.06144f
C113 m3_n3682_13404# m3_n3682_13516# 0.06144f
C114 m3_n3906_22476# m3_n3906_22588# 0.06144f
C115 m3_n3682_14076# m3_n3682_13964# 0.06144f
C116 m3_n3794_16092# m3_n3682_16092# 0.06144f
C117 m3_n3682_n1380# m3_n3682_n1268# 0.06144f
C118 m3_n3794_21468# m3_n3794_21580# 0.06144f
C119 m3_n3794_15644# m3_n3794_15532# 0.06144f
C120 m3_n3906_n9220# m3_n3794_n9220# 0.06144f
C121 m3_n3682_n3620# m3_n3682_n3732# 0.06144f
C122 m3_n3906_n3732# m3_n3794_n3732# 0.06144f
C123 m3_n3682_n16612# m3_n3682_n16500# 0.06144f
C124 m3_n3794_n4852# m3_n3794_n4964# 0.06144f
C125 m3_n3682_636# m3_n3682_748# 0.06144f
C126 m3_n3794_n16052# m3_n3682_n16052# 0.06144f
C127 m3_n3906_n8100# m3_n3906_n7988# 0.06144f
C128 m3_n3906_n15828# m3_n3906_n15940# 0.06144f
C129 x13/X x15/X 0.29019f
C130 m3_n3906_9260# m3_n3794_9260# 0.06144f
C131 m3_n3682_n260# m3_n3386_n6343# 0.0178f
C132 m3_n3794_n11012# m3_n3794_n10900# 0.06144f
C133 m3_n3794_n16500# m3_n3794_n16388# 0.06144f
C134 m3_n3794_n5188# m3_n3682_n5188# 0.06144f
C135 m3_n3682_5900# m3_n3682_6012# 0.06144f
C136 m3_n3906_n5188# m3_n3906_n5300# 0.06144f
C137 m3_n3906_n9444# m3_n3794_n9444# 0.06144f
C138 m3_n3906_n2164# m3_n3906_n2276# 0.06144f
C139 m3_n3906_n18068# m3_n3794_n18068# 0.06144f
C140 m3_n3682_2540# m3_n3682_2428# 0.06144f
C141 m3_n3682_n18404# m3_n3682_n18292# 0.06144f
C142 m3_n3794_8924# m3_n3794_9036# 0.06144f
C143 m3_n3794_n11012# m3_n3794_n11124# 0.06144f
C144 m3_n3794_n10228# m3_n3794_n10340# 0.06144f
C145 m3_n3906_n15604# m3_n3906_n15716# 0.06144f
C146 m3_n3906_16764# m3_n3794_16764# 0.06144f
C147 m3_n3682_n2388# m3_n3682_n2500# 0.06144f
C148 m3_n3682_16876# m3_n3682_16764# 0.06144f
C149 m3_n3906_11948# m3_n3906_12060# 0.06144f
C150 m3_n3906_12396# m3_n3906_12508# 0.06144f
C151 m3_n3794_7580# m3_n3794_7468# 0.06144f
C152 m3_n3906_n18740# m3_n3906_n18628# 0.06144f
C153 m3_n3906_n4404# m3_n3794_n4404# 0.06144f
C154 m3_n3682_n4292# m3_n3682_n4404# 0.06144f
C155 m3_n3906_14748# m3_n3906_14636# 0.06144f
C156 m3_n3794_n16276# m3_n3794_n16388# 0.06144f
C157 m3_n3682_n6196# m3_n3386_n6343# 0.0178f
C158 m3_n3794_n17732# m3_n3794_n17844# 0.06144f
C159 m3_n3794_17884# m3_n3682_17884# 0.06144f
C160 m3_n3682_12172# m3_n3794_12172# 0.06144f
C161 m3_n3906_12060# m3_n3906_12172# 0.06144f
C162 m3_n3682_8924# m3_n3682_8812# 0.06144f
C163 m3_n3682_n13252# m3_n3682_n13140# 0.06144f
C164 m3_n3906_n19300# m3_n3794_n19300# 0.06144f
C165 m3_n3906_n13700# m3_n3794_n13700# 0.06144f
C166 m3_n3682_2652# m3_n3682_2764# 0.06144f
C167 m3_n3794_n16612# m3_n3682_n16612# 0.06144f
C168 m3_n3682_n7764# m3_n3682_n7876# 0.06144f
C169 m3_n3906_n16612# m3_n3906_n16724# 0.06144f
C170 m3_n3906_20460# m3_n3794_20460# 0.06144f
C171 m3_n3682_15084# m3_n3682_15196# 0.06144f
C172 m3_n3906_n8324# m3_n3794_n8324# 0.06144f
C173 m3_n3794_20348# m3_n3682_20348# 0.06144f
C174 m3_n3794_n14596# m3_n3682_n14596# 0.06144f
C175 m3_n3906_n14596# m3_n3906_n14708# 0.06144f
C176 m3_n3794_16540# m3_n3794_16428# 0.06144f
C177 m3_n3794_n18516# m3_n3794_n18404# 0.06144f
C178 m3_n3906_n12356# m3_n3794_n12356# 0.06144f
C179 m3_n3906_n9220# m3_n3906_n9108# 0.06144f
C180 m3_n3794_10380# m3_n3794_10492# 0.06144f
C181 m3_n3794_20012# m3_n3794_20124# 0.06144f
C182 m3_n3794_16316# m3_n3794_16204# 0.06144f
C183 m3_n3906_6124# m3_n3906_6236# 0.06144f
C184 m3_n3794_5004# m3_n3682_5004# 0.06144f
C185 m3_n3906_21692# m3_n3906_21580# 0.06144f
C186 m3_n3682_9036# m3_n3682_9148# 0.06144f
C187 m3_n3906_n1828# m3_n3794_n1828# 0.06144f
C188 m3_n3794_16876# m3_n3794_16764# 0.06144f
C189 m3_n3682_4444# m3_n3386_n6343# 0.0178f
C190 m3_n3794_n17172# m3_n3682_n17172# 0.06144f
C191 m3_n3906_n13252# m3_n3794_n13252# 0.06144f
C192 m3_n3682_1868# m3_n3386_n6343# 0.0178f
C193 m3_n3794_3548# m3_n3682_3548# 0.06144f
C194 m3_n3906_3548# m3_n3906_3436# 0.06144f
C195 m3_n3682_21356# m3_n3682_21244# 0.06144f
C196 m3_n3906_21580# m3_n3794_21580# 0.06144f
C197 m3_n3906_21244# m3_n3794_21244# 0.06144f
C198 m3_n3794_14972# m3_n3794_14860# 0.06144f
C199 m3_n3906_3996# m3_n3906_3884# 0.06144f
C200 m3_n3682_n19748# m3_n3682_n19636# 0.06144f
C201 m3_n3794_3996# m3_n3682_3996# 0.06144f
C202 m3_n3794_n932# m3_n3682_n932# 0.06144f
C203 m3_n3906_n932# m3_n3906_n1044# 0.06144f
C204 m3_n3794_n2612# m3_n3682_n2612# 0.06144f
C205 m3_n3794_n15380# m3_n3682_n15380# 0.06144f
C206 m3_n3794_n596# m3_n3682_n596# 0.06144f
C207 m3_n3794_8252# m3_n3794_8140# 0.06144f
C208 m3_n3906_n13588# m3_n3906_n13700# 0.06144f
C209 m3_n3682_n12580# m3_n3682_n12468# 0.06144f
C210 m3_n3906_n13924# m3_n3794_n13924# 0.06144f
C211 m3_n3682_n14932# m3_n3682_n15044# 0.06144f
C212 m3_n3682_n484# m3_n3386_n6343# 0.0178f
C213 m3_n3794_n10004# m3_n3682_n10004# 0.06144f
C214 m3_n3906_1084# m3_n3794_1084# 0.06144f
C215 m3_n3682_15420# m3_n3682_15308# 0.06144f
C216 m3_n3794_17660# m3_n3682_17660# 0.06144f
C217 m3_n3906_5452# m3_n3906_5340# 0.06144f
C218 m3_n3682_n11796# m3_n3682_n11908# 0.06144f
C219 x9/Y VDPWR 3.2205f
C220 m3_n3906_n16276# m3_n3794_n16276# 0.06144f
C221 m3_n3682_n16164# m3_n3682_n16276# 0.06144f
C222 m3_n3682_7356# m3_n3682_7468# 0.06144f
C223 m3_n3794_7356# m3_n3906_7356# 0.06144f
C224 m3_n3906_n19188# m3_n3794_n19188# 0.06144f
C225 m3_n3794_n6308# m3_n3682_n6308# 0.06144f
C226 m3_n3906_n6308# m3_n3906_n6420# 0.06144f
C227 m3_n3682_n15268# m3_n3794_n15268# 0.06144f
C228 m3_n3906_n15380# m3_n3906_n15268# 0.06144f
C229 m3_n3794_76# m3_n3794_n36# 0.06144f
C230 m3_n3794_n8324# m3_n3794_n8436# 0.06144f
C231 m3_n3794_n12916# m3_n3906_n12916# 0.06144f
C232 m3_n3682_n12916# m3_n3682_n12804# 0.06144f
C233 m3_n3794_17324# m3_n3794_17436# 0.06144f
C234 m3_n3906_16540# m3_n3906_16652# 0.06144f
C235 m3_n3682_16652# m3_n3794_16652# 0.06144f
C236 pincelazo_0/m4_0_1537# VDPWR 0
C237 m3_n3906_n10340# m3_n3794_n10340# 0.06144f
C238 m3_n3906_5900# m3_n3794_5900# 0.06144f
C239 m3_n3794_n19860# m3_n3794_n19748# 0.06144f
C240 m3_n3682_n13924# m3_n3794_n13924# 0.06144f
C241 m3_n3906_n14036# m3_n3906_n13924# 0.06144f
C242 m3_n3794_6796# m3_n3682_6796# 0.06144f
C243 m3_n3906_6796# m3_n3906_6684# 0.06144f
C244 m3_n3794_n6644# m3_n3682_n6644# 0.06144f
C245 m3_n3682_5676# m3_n3386_n6343# 0.0178f
C246 m3_n3906_11388# m3_n3794_11388# 0.06144f
C247 m3_n3682_11500# m3_n3682_11388# 0.06144f
C248 m3_n3906_7468# m3_n3794_7468# 0.06144f
C249 m3_n3386_n6343# ardilla_0/m3_0_2333# 0.17996f
C250 m3_n3794_n18964# m3_n3682_n18964# 0.06144f
C251 m3_n3906_n16500# m3_n3794_n16500# 0.06144f
C252 m3_n3682_n16388# m3_n3682_n16500# 0.06144f
C253 m3_n3794_n1604# m3_n3794_n1492# 0.06144f
C254 m3_n3906_188# m3_n3794_188# 0.06144f
C255 pincelazo_0/m4_0_1537# pincelazo_0/m4_3975_1537# 0.42808f
C256 m3_n3906_n4068# m3_n3794_n4068# 0.06144f
C257 m3_n3794_12732# m3_n3682_12732# 0.06144f
C258 m3_n3682_1980# m3_n3682_2092# 0.06144f
C259 m3_n3794_1196# m3_n3682_1196# 0.06144f
C260 m3_n3906_7692# m3_n3906_7580# 0.06144f
C261 m3_n3794_7692# m3_n3682_7692# 0.06144f
C262 m3_n3906_17996# m3_n3906_18108# 0.06144f
C263 m3_n3682_7244# m3_n3682_7356# 0.06144f
C264 m3_n3682_22364# m3_n3682_22252# 0.06144f
C265 m3_n3682_n12356# m3_n3682_n12468# 0.06144f
C266 m3_n3906_n12468# m3_n3794_n12468# 0.06144f
C267 m3_n3682_17324# m3_n3682_17436# 0.06144f
C268 m3_n3682_21804# m3_n3682_21692# 0.06144f
C269 m3_n3906_n16948# m3_n3906_n16836# 0.06144f
C270 m3_n3682_4892# m3_n3682_5004# 0.06144f
C271 m3_n3906_21692# m3_n3794_21692# 0.06144f
C272 m3_n3682_n16836# m3_n3794_n16836# 0.06144f
C273 m3_n3794_1532# m3_n3794_1420# 0.06144f
C274 m3_n3906_8700# m3_n3906_8812# 0.06144f
C275 m3_n3682_8812# m3_n3794_8812# 0.06144f
C276 x8/A VDPWR 4.59856f
C277 m3_n3682_7580# m3_n3682_7468# 0.06144f
C278 m3_n3386_n6343# m3_n3682_n6308# 0.0178f
C279 m3_n3682_n16388# m3_n3682_n16276# 0.06144f
C280 m3_n3682_10156# m3_n3682_10268# 0.06144f
C281 m3_n3906_n17284# m3_n3906_n17172# 0.06144f
C282 m3_n3794_n1380# m3_n3794_n1492# 0.06144f
C283 m3_n3794_4668# m3_n3794_4780# 0.06144f
C284 m3_n3682_n8884# m3_n3682_n8772# 0.06144f
C285 m3_n3794_n8884# m3_n3906_n8884# 0.06144f
C286 m3_n3794_21580# m3_n3794_21692# 0.06144f
C287 m3_n3906_13852# m3_n3906_13740# 0.06144f
C288 m3_n3906_n17732# m3_n3794_n17732# 0.06144f
C289 m3_n3794_6796# m3_n3794_6908# 0.06144f
C290 m3_n3794_n6084# m3_n3794_n5972# 0.06144f
C291 m3_n3906_2428# m3_n3906_2540# 0.06144f
C292 m3_n3794_n14932# m3_n3682_n14932# 0.06144f
C293 m3_n3682_18668# m3_n3682_18780# 0.06144f
C294 m3_n3794_n8436# m3_n3682_n8436# 0.06144f
C295 m3_n3906_5228# m3_n3906_5116# 0.06144f
C296 m3_n3906_n16612# m3_n3906_n16500# 0.06144f
C297 m3_n3794_12844# m3_n3794_12732# 0.06144f
C298 x9/Y x8/A 1.67966f
C299 m3_n3906_20348# m3_n3794_20348# 0.06144f
C300 m3_n3682_20460# m3_n3682_20348# 0.06144f
C301 m3_n3906_n3396# m3_n3794_n3396# 0.06144f
C302 m3_n3794_n6532# m3_n3794_n6644# 0.06144f
C303 m3_n3682_188# m3_n3682_76# 0.06144f
C304 m3_n3906_76# m3_n3794_76# 0.06144f
C305 m3_n3906_22476# m3_n3906_22364# 0.06144f
C306 m3_n3794_22476# m3_n3682_22476# 0.06144f
C307 m3_n3682_n17732# m3_n3682_n17844# 0.06144f
C308 m3_n3682_20236# m3_n3682_20124# 0.06144f
C309 m3_n3906_3548# m3_n3906_3660# 0.06144f
C310 m3_n3794_16316# m3_n3682_16316# 0.06144f
C311 m3_n3906_20124# m3_n3794_20124# 0.06144f
C312 m3_n3794_n19300# m3_n3682_n19300# 0.06144f
C313 m3_n3794_n9108# m3_n3794_n9220# 0.06144f
C314 m3_n3682_n4516# m3_n3682_n4404# 0.06144f
C315 m3_n3794_n18292# m3_n3794_n18180# 0.06144f
C316 m3_n3906_n1268# m3_n3906_n1156# 0.06144f
C317 m3_n3682_6348# m3_n3682_6460# 0.06144f
C318 m3_n3682_n1156# m3_n3794_n1156# 0.06144f
C319 m3_n3794_13180# m3_n3682_13180# 0.06144f
C320 m3_n3794_n11796# m3_n3682_n11796# 0.06144f
C321 m3_n3682_n18516# m3_n3682_n18404# 0.06144f
C322 m3_n3794_300# m3_n3794_188# 0.06144f
C323 m3_n3794_8364# m3_n3794_8476# 0.06144f
C324 m3_n3906_n5188# m3_n3906_n5076# 0.06144f
C325 m3_n3906_18556# m3_n3794_18556# 0.06144f
C326 m3_n3682_18668# m3_n3682_18556# 0.06144f
C327 pincelazo_0/m4_2662_1725# pincelazo_0/m4_0_1537# 0.51475f
C328 m3_n3906_412# m3_n3794_412# 0.06144f
C329 m3_n3906_20012# m3_n3906_19900# 0.06144f
C330 m3_n3794_20012# m3_n3682_20012# 0.06144f
C331 m3_n3906_n18852# m3_n3906_n18740# 0.06144f
C332 m3_n3794_5564# m3_n3794_5452# 0.06144f
C333 m3_n3794_3212# m3_n3794_3324# 0.06144f
C334 m3_n3906_12844# m3_n3794_12844# 0.06144f
C335 m3_n3906_21356# m3_n3906_21468# 0.06144f
C336 m3_n3794_14748# m3_n3682_14748# 0.06144f
C337 m3_n3906_n17620# m3_n3794_n17620# 0.06144f
C338 m3_n3794_3100# m3_n3794_2988# 0.06144f
C339 m3_n3794_20572# m3_n3906_20572# 0.06144f
C340 m3_n3794_n16724# m3_n3906_n16724# 0.06144f
C341 m3_n3682_n16724# m3_n3682_n16612# 0.06144f
C342 m3_n3682_n2724# m3_n3682_n2612# 0.06144f
C343 m3_n3682_20572# m3_n3682_20684# 0.06144f
C344 m3_n3682_6348# m3_n3682_6236# 0.06144f
C345 m3_n3906_6236# m3_n3794_6236# 0.06144f
C346 m3_n3906_n1268# m3_n3794_n1268# 0.06144f
C347 m3_n3682_n3060# m3_n3682_n3172# 0.06144f
C348 m3_n3794_22140# m3_n3794_22252# 0.06144f
C349 m3_n3906_19788# m3_n3794_19788# 0.06144f
C350 m3_n3682_n1156# m3_n3682_n1268# 0.06144f
C351 VDPWR x15/a_109_47# 0.02997f
C352 m3_n3906_10828# m3_n3794_10828# 0.06144f
C353 m3_n3794_n18628# m3_n3794_n18516# 0.06144f
C354 m3_n3682_16876# m3_n3794_16876# 0.06144f
C355 m3_n3906_16764# m3_n3906_16876# 0.06144f
C356 m3_n3682_14636# m3_n3682_14748# 0.06144f
C357 m3_n3794_9596# m3_n3682_9596# 0.06144f
C358 m3_n3794_11836# m3_n3682_11836# 0.06144f
C359 m3_n3794_n13028# m3_n3794_n13140# 0.06144f
C360 m3_n3682_2316# m3_n3386_n6343# 0.0178f
C361 m3_n3906_n9668# m3_n3794_n9668# 0.06144f
C362 m3_n3794_7468# m3_n3682_7468# 0.06144f
C363 m3_n3906_22028# m3_n3794_22028# 0.06144f
C364 m3_n3906_7468# m3_n3906_7356# 0.06144f
C365 m3_n3794_21692# m3_n3682_21692# 0.06144f
C366 m3_n3906_n6532# m3_n3794_n6532# 0.06144f
C367 m3_n3794_13628# m3_n3682_13628# 0.06144f
C368 m3_n3794_n9108# m3_n3906_n9108# 0.06144f
C369 m3_n3682_n9108# m3_n3682_n8996# 0.06144f
C370 m3_n3794_n6868# m3_n3794_n6980# 0.06144f
C371 m3_n3794_16540# m3_n3794_16652# 0.06144f
C372 m3_n3794_16092# m3_n3794_15980# 0.06144f
C373 m3_n3794_n10564# m3_n3794_n10452# 0.06144f
C374 m3_n3906_n9668# m3_n3906_n9556# 0.06144f
C375 m3_n3682_19004# m3_n3682_18892# 0.06144f
C376 m3_n3906_n16164# m3_n3794_n16164# 0.06144f
C377 m3_n3794_n6868# m3_n3794_n6756# 0.06144f
C378 m3_n3794_n1156# m3_n3794_n1044# 0.06144f
C379 x9/Y x15/a_109_47# 0
C380 m3_n3794_6348# m3_n3794_6460# 0.06144f
C381 m3_n3794_n13812# m3_n3794_n13700# 0.06144f
C382 m3_n3794_n16500# m3_n3682_n16500# 0.06144f
C383 m3_n3794_15532# m3_n3682_15532# 0.06144f
C384 m3_n3682_n19860# m3_n3682_n19748# 0.06144f
C385 m3_n3906_15532# m3_n3906_15420# 0.06144f
C386 m3_n3906_n17508# m3_n3794_n17508# 0.06144f
C387 m3_n3794_2092# m3_n3682_2092# 0.06144f
C388 m3_n3682_5788# m3_n3386_n6343# 0.0178f
C389 m3_n3794_13852# m3_n3794_13964# 0.06144f
C390 m3_n3906_n16948# m3_n3906_n17060# 0.06144f
C391 m3_n3794_3884# m3_n3906_3884# 0.06144f
C392 m3_n3682_3100# m3_n3386_n6343# 0.0178f
C393 m3_n3682_3884# m3_n3682_3996# 0.06144f
C394 pincelazo_0/m4_0_1537# x15/a_109_47# 0.00688f
C395 m3_n3906_n3844# m3_n3906_n3956# 0.06144f
C396 m3_n3906_3548# m3_n3794_3548# 0.06144f
C397 m3_n3794_n3844# m3_n3682_n3844# 0.06144f
C398 m3_n3794_300# m3_n3682_300# 0.06144f
C399 m3_n3682_n10788# m3_n3682_n10900# 0.06144f
C400 m3_n3906_n10900# m3_n3794_n10900# 0.06144f
C401 m3_n3682_n3284# m3_n3682_n3172# 0.06144f
C402 m3_n3906_15084# m3_n3794_15084# 0.06144f
C403 m3_n3906_16876# m3_n3794_16876# 0.06144f
C404 m3_n3794_n3284# m3_n3906_n3284# 0.06144f
C405 m3_n3794_n14260# m3_n3794_n14148# 0.06144f
C406 m3_n3682_n15828# m3_n3682_n15716# 0.06144f
C407 m3_n3794_n15828# m3_n3906_n15828# 0.06144f
C408 m3_n3794_9708# m3_n3794_9596# 0.06144f
C409 m3_n3794_n148# m3_n3682_n148# 0.06144f
C410 m3_n3682_2652# m3_n3794_2652# 0.06144f
C411 m3_n3906_2540# m3_n3906_2652# 0.06144f
C412 m3_n3682_21804# m3_n3682_21916# 0.06144f
C413 m3_n3794_8476# m3_n3794_8588# 0.06144f
C414 m3_n3906_n11908# m3_n3794_n11908# 0.06144f
C415 m3_n3794_5228# m3_n3794_5116# 0.06144f
C416 m3_n3794_412# m3_n3682_412# 0.06144f
C417 m3_n3794_6348# m3_n3794_6236# 0.06144f
C418 m3_n3906_n4516# m3_n3794_n4516# 0.06144f
C419 m3_n3906_412# m3_n3906_300# 0.06144f
C420 m3_n3794_n19972# m3_n3794_n19860# 0.06144f
C421 m3_n3794_15868# m3_n3682_15868# 0.06144f
C422 m3_n3794_22812# m3_n3794_22924# 0.06144f
C423 m3_n3794_n1044# m3_n3906_n1044# 0.06144f
C424 m3_n3682_n1044# m3_n3682_n932# 0.06144f
C425 m3_n3906_13180# m3_n3906_13068# 0.06144f
C426 m3_n3682_n3172# m3_n3386_n6343# 0.0178f
C427 m3_n3906_15308# m3_n3906_15420# 0.06144f
C428 m3_n3794_n16276# m3_n3682_n16276# 0.06144f
C429 m3_n3794_n16612# m3_n3794_n16500# 0.06144f
C430 m3_n3906_18556# m3_n3906_18444# 0.06144f
C431 m3_n3794_n17732# m3_n3682_n17732# 0.06144f
C432 m3_n3794_n12580# m3_n3794_n12468# 0.06144f
C433 m3_n3682_4220# m3_n3386_n6343# 0.0178f
C434 m3_n3906_21132# m3_n3794_21132# 0.06144f
C435 m3_n3682_21132# m3_n3682_21244# 0.06144f
C436 m3_n3794_15644# m3_n3906_15644# 0.06144f
C437 m3_n3682_22140# m3_n3682_22028# 0.06144f
C438 m3_n3682_16092# m3_n3682_15980# 0.06144f
C439 m3_n3682_15644# m3_n3682_15756# 0.06144f
C440 m3_n3906_n10900# m3_n3906_n10788# 0.06144f
C441 m3_n3682_n10788# m3_n3794_n10788# 0.06144f
C442 m3_n3682_9372# m3_n3682_9260# 0.06144f
C443 m3_n3682_22476# m3_n3682_22364# 0.06144f
C444 m3_n3906_22364# m3_n3794_22364# 0.06144f
C445 m3_n3682_n148# m3_n3682_n36# 0.06144f
C446 m3_n3794_n148# m3_n3906_n148# 0.06144f
C447 m3_n3794_19564# m3_n3794_19452# 0.06144f
C448 m3_n3906_6348# m3_n3906_6460# 0.06144f
C449 m3_n3906_9708# m3_n3794_9708# 0.06144f
C450 m3_n3906_n2948# m3_n3794_n2948# 0.06144f
C451 m3_n3682_n596# m3_n3682_n708# 0.06144f
C452 m3_n3906_15532# m3_n3794_15532# 0.06144f
C453 m3_n3794_n3060# m3_n3794_n2948# 0.06144f
C454 m3_n3906_6572# m3_n3906_6684# 0.06144f
C455 m3_n3682_n18292# m3_n3682_n18180# 0.06144f
C456 m3_n3794_n3060# m3_n3682_n3060# 0.06144f
C457 m3_n3682_n12020# m3_n3682_n11908# 0.06144f
C458 m3_n3794_n12020# m3_n3906_n12020# 0.06144f
C459 m3_n3906_7244# m3_n3794_7244# 0.06144f
C460 x13/X x4/A 0
C461 m3_n3906_11948# m3_n3906_11836# 0.06144f
C462 m3_n3794_n5972# m3_n3682_n5972# 0.06144f
C463 m3_n3794_11948# m3_n3682_11948# 0.06144f
C464 m3_n3794_n4068# m3_n3794_n4180# 0.06144f
C465 m3_n3906_n16612# m3_n3794_n16612# 0.06144f
C466 m3_n3682_n1604# m3_n3682_n1492# 0.06144f
C467 m3_n3906_20684# m3_n3794_20684# 0.06144f
C468 m3_n3682_4892# m3_n3386_n6343# 0.0178f
C469 m3_n3794_n8772# m3_n3794_n8884# 0.06144f
C470 m3_n3682_16540# m3_n3682_16428# 0.06144f
C471 m3_n3794_19900# m3_n3794_19788# 0.06144f
C472 m3_n3682_n2612# m3_n3386_n6343# 0.0178f
C473 m3_n3682_n596# m3_n3386_n6343# 0.0178f
C474 m3_n3386_n6343# x9/A 16.04852f
C475 m3_n3794_n14484# m3_n3682_n14484# 0.06144f
C476 m3_n3794_10492# m3_n3682_10492# 0.06144f
C477 m3_n3794_n13588# m3_n3682_n13588# 0.06144f
C478 m3_n3682_14860# m3_n3682_14748# 0.06144f
C479 m3_n3906_14748# m3_n3794_14748# 0.06144f
C480 m3_n3794_n8212# m3_n3682_n8212# 0.06144f
C481 x14/X x14/a_109_47# 0.03588f
C482 m3_n3682_n15268# m3_n3682_n15156# 0.06144f
C483 m3_n3682_17996# m3_n3794_17996# 0.06144f
C484 m3_n3906_n12356# m3_n3906_n12468# 0.06144f
C485 m3_n3906_17884# m3_n3906_17996# 0.06144f
C486 m3_n3794_n12356# m3_n3682_n12356# 0.06144f
C487 m3_n3794_n15492# m3_n3794_n15380# 0.06144f
C488 m3_n3682_14412# m3_n3682_14300# 0.06144f
C489 m3_n3682_n18628# m3_n3682_n18516# 0.06144f
C490 m3_n3906_14300# m3_n3794_14300# 0.06144f
C491 m3_n3386_n6343# m3_n3682_2428# 0.0178f
C492 m3_n3906_17100# m3_n3906_17212# 0.06144f
C493 m3_n3794_n10452# m3_n3906_n10452# 0.06144f
C494 m3_n3794_n2388# m3_n3794_n2276# 0.06144f
C495 m3_n3682_n10452# m3_n3682_n10340# 0.06144f
C496 m3_n3794_n9108# m3_n3682_n9108# 0.06144f
C497 m3_n3682_5116# m3_n3682_5228# 0.06144f
C498 m3_n3906_11500# m3_n3794_11500# 0.06144f
C499 m3_n3794_n4852# m3_n3794_n4740# 0.06144f
C500 m3_n3906_n12804# m3_n3794_n12804# 0.06144f
C501 m3_n3906_n6308# m3_n3794_n6308# 0.06144f
C502 m3_n3906_n18964# m3_n3906_n18852# 0.06144f
C503 m3_n3794_n12244# m3_n3682_n12244# 0.06144f
C504 m3_n3794_2204# m3_n3682_2204# 0.06144f
C505 m3_n3906_2204# m3_n3906_2092# 0.06144f
C506 m3_n3794_4556# m3_n3682_4556# 0.06144f
C507 m3_n3682_5564# m3_n3386_n6343# 0.0178f
C508 m3_n3794_6460# m3_n3794_6572# 0.06144f
C509 m3_n3794_n18068# m3_n3682_n18068# 0.06144f
C510 m3_n3794_8252# m3_n3682_8252# 0.06144f
C511 m3_n3906_n19524# m3_n3794_n19524# 0.06144f
C512 m3_n3794_15980# m3_n3794_15868# 0.06144f
C513 m3_n3682_6684# m3_n3682_6796# 0.06144f
C514 m3_n3794_6684# m3_n3906_6684# 0.06144f
C515 m3_n3386_n6343# m3_n3682_n3620# 0.0178f
C516 m3_n3906_21804# m3_n3906_21916# 0.06144f
C517 m3_n3906_n13812# m3_n3906_n13700# 0.06144f
C518 m3_n3906_19340# m3_n3794_19340# 0.06144f
C519 m3_n3682_n13700# m3_n3794_n13700# 0.06144f
C520 m3_n3906_15308# m3_n3794_15308# 0.06144f
C521 m3_n3906_n13588# m3_n3906_n13476# 0.06144f
C522 m3_n3682_n7540# m3_n3682_n7428# 0.06144f
C523 m3_n3794_n7540# m3_n3906_n7540# 0.06144f
C524 m3_n3682_n13476# m3_n3794_n13476# 0.06144f
C525 m3_n3794_n17508# m3_n3682_n17508# 0.06144f
C526 m3_n3794_n18740# m3_n3794_n18628# 0.06144f
C527 m3_n3682_8588# m3_n3682_8700# 0.06144f
C528 m3_n3794_n9332# m3_n3906_n9332# 0.06144f
C529 m3_n3794_n14148# m3_n3794_n14036# 0.06144f
C530 m3_n3682_n9332# m3_n3682_n9220# 0.06144f
C531 m3_n3794_5564# m3_n3794_5676# 0.06144f
C532 m3_n3682_14188# m3_n3682_14300# 0.06144f
C533 m3_n3906_n17956# m3_n3906_n18068# 0.06144f
C534 m3_n3682_n36# m3_n3386_n6343# 0.0178f
C535 m3_n3906_9932# m3_n3906_10044# 0.06144f
C536 m3_n3794_n14372# m3_n3794_n14484# 0.06144f
C537 x16/X x14/X 3.56706f
C538 m3_n3794_2316# m3_n3794_2428# 0.06144f
C539 m3_n3794_n2724# m3_n3794_n2836# 0.06144f
C540 m3_n3682_n8884# m3_n3682_n8996# 0.06144f
C541 m3_n3794_76# m3_n3682_76# 0.06144f
C542 m3_n3794_1084# m3_n3682_1084# 0.06144f
C543 m3_n3906_1084# m3_n3906_972# 0.06144f
C544 m3_n3386_n6343# m3_n3682_n4292# 0.0178f
C545 m3_n3794_n3284# m3_n3682_n3284# 0.06144f
C546 m3_n3682_1532# m3_n3386_n6343# 0.0178f
C547 m3_n3906_n5412# m3_n3906_n5524# 0.06144f
C548 m3_n3794_n5412# m3_n3682_n5412# 0.06144f
C549 m3_n3682_n19972# m3_n3682_n19860# 0.06144f
C550 m3_n3906_10156# m3_n3794_10156# 0.06144f
C551 m3_n3906_19116# m3_n3906_19228# 0.06144f
C552 m3_n3794_n7540# m3_n3794_n7428# 0.06144f
C553 x16/a_109_47# x9/A 0
C554 m3_n3794_12508# m3_n3682_12508# 0.06144f
C555 m3_n3794_n1828# m3_n3794_n1716# 0.06144f
C556 m3_n3386_n6343# m3_n3682_2092# 0.0178f
C557 m3_n3794_n260# m3_n3794_n372# 0.06144f
C558 m3_n3906_14972# m3_n3906_15084# 0.06144f
C559 m3_n3906_n372# m3_n3794_n372# 0.06144f
C560 m3_n3682_15084# m3_n3794_15084# 0.06144f
C561 m3_n3682_n260# m3_n3682_n372# 0.06144f
C562 x16/X x14/a_109_47# 0
C563 m3_n3906_n2052# m3_n3906_n1940# 0.06144f
C564 m3_n3794_14076# m3_n3682_14076# 0.06144f
C565 m3_n3794_8364# m3_n3794_8252# 0.06144f
C566 m3_n3682_6572# m3_n3794_6572# 0.06144f
C567 m3_n3906_n19412# m3_n3794_n19412# 0.06144f
C568 m3_n3906_6460# m3_n3906_6572# 0.06144f
C569 m3_n3906_14860# m3_n3794_14860# 0.06144f
C570 m3_n3906_1196# m3_n3794_1196# 0.06144f
C571 m3_n3682_1308# m3_n3682_1196# 0.06144f
C572 m3_n3906_n11236# m3_n3906_n11124# 0.06144f
C573 m3_n3682_n7540# m3_n3682_n7652# 0.06144f
C574 m3_n3794_1644# m3_n3682_1644# 0.06144f
C575 m3_n3794_15868# m3_n3906_15868# 0.06144f
C576 m3_n3682_15868# m3_n3682_15980# 0.06144f
C577 m3_n3682_11724# m3_n3682_11836# 0.06144f
C578 m3_n3682_n4180# m3_n3682_n4292# 0.06144f
C579 m3_n3682_4668# m3_n3386_n6343# 0.0178f
C580 m3_n3682_1868# m3_n3682_1756# 0.06144f
C581 m3_n3906_n6868# m3_n3906_n6980# 0.06144f
C582 m3_n3794_n13812# m3_n3682_n13812# 0.06144f
C583 m3_n3794_n19188# m3_n3682_n19188# 0.06144f
C584 m3_n3794_19900# m3_n3682_19900# 0.06144f
C585 m3_n3682_4220# m3_n3682_4108# 0.06144f
C586 m3_n3906_4108# m3_n3794_4108# 0.06144f
C587 m3_n3906_6796# m3_n3906_6908# 0.06144f
C588 m3_n3794_17100# m3_n3794_17212# 0.06144f
C589 m3_n3906_3772# m3_n3906_3884# 0.06144f
C590 m3_n3794_14524# m3_n3794_14636# 0.06144f
C591 m3_n3906_3100# m3_n3906_2988# 0.06144f
C592 m3_n3906_n12804# m3_n3906_n12692# 0.06144f
C593 m3_n3794_3100# m3_n3682_3100# 0.06144f
C594 m3_n3906_n6868# m3_n3906_n6756# 0.06144f
C595 m3_n3794_n2388# m3_n3906_n2388# 0.06144f
C596 m3_n3682_n2388# m3_n3682_n2276# 0.06144f
C597 m3_n3906_n1604# m3_n3794_n1604# 0.06144f
C598 m3_n3682_n6756# m3_n3794_n6756# 0.06144f
C599 m3_n3906_n14372# m3_n3794_n14372# 0.06144f
C600 m3_n3794_19676# m3_n3906_19676# 0.06144f
C601 m3_n3682_19676# m3_n3682_19788# 0.06144f
C602 m3_n3794_n2388# m3_n3794_n2500# 0.06144f
C603 m3_n3906_4892# m3_n3906_5004# 0.06144f
C604 m3_n3794_n11572# m3_n3682_n11572# 0.06144f
C605 m3_n3906_n1828# m3_n3906_n1716# 0.06144f
C606 m3_n3682_n8100# m3_n3682_n7988# 0.06144f
C607 VDPWR x13/a_109_47# 0.03499f
C608 m3_n3794_n6420# m3_n3794_n6532# 0.06144f
C609 m3_n3794_n5188# m3_n3794_n5300# 0.06144f
C610 m3_n3906_15980# m3_n3794_15980# 0.06144f
C611 m3_n3794_4332# m3_n3682_4332# 0.06144f
C612 m3_n3682_4556# m3_n3386_n6343# 0.0178f
C613 m3_n3794_n8100# m3_n3794_n7988# 0.06144f
C614 m3_n3906_8364# m3_n3794_8364# 0.06144f
C615 m3_n3794_n14708# m3_n3794_n14596# 0.06144f
C616 m3_n3906_14188# m3_n3906_14300# 0.06144f
C617 m3_n3682_n9556# m3_n3682_n9668# 0.06144f
C618 m3_n3794_19228# m3_n3794_19340# 0.06144f
C619 m3_n3794_6012# m3_n3682_6012# 0.06144f
C620 m3_n3682_7804# m3_n3682_7692# 0.06144f
C621 m3_n3682_6572# m3_n3682_6684# 0.06144f
C622 VDPWR x15/X 0.07538f
C623 m3_n3794_n16724# m3_n3794_n16612# 0.06144f
C624 m3_n3794_n11572# m3_n3794_n11684# 0.06144f
C625 m3_n3682_76# m3_n3386_n6343# 0.0178f
C626 m3_n3794_21916# m3_n3682_21916# 0.06144f
C627 m3_n3794_6908# m3_n3794_7020# 0.06144f
C628 m3_n3794_n17284# m3_n3794_n17172# 0.06144f
C629 m3_n3682_n484# m3_n3682_n372# 0.06144f
C630 x9/Y x13/a_109_47# 0.0509f
C631 m3_n3794_19452# m3_n3794_19340# 0.06144f
C632 m3_n3794_n708# m3_n3794_n820# 0.06144f
C633 m3_n3906_n1380# m3_n3794_n1380# 0.06144f
C634 m3_n3906_n12132# m3_n3906_n12244# 0.06144f
C635 m3_n3906_9036# m3_n3794_9036# 0.06144f
C636 m3_n3794_n12132# m3_n3682_n12132# 0.06144f
C637 m3_n3794_412# m3_n3794_524# 0.06144f
C638 m3_n3682_4444# m3_n3794_4444# 0.06144f
C639 m3_n3906_4332# m3_n3906_4444# 0.06144f
C640 m3_n3794_11500# m3_n3682_11500# 0.06144f
C641 m3_n3906_11500# m3_n3906_11388# 0.06144f
C642 m3_n3682_1644# m3_n3386_n6343# 0.0178f
C643 m3_n3794_n7316# m3_n3906_n7316# 0.06144f
C644 m3_n3682_n7316# m3_n3682_n7204# 0.06144f
C645 m3_n3794_n19524# m3_n3682_n19524# 0.06144f
C646 m3_n3794_3660# m3_n3682_3660# 0.06144f
C647 m3_n3794_n4180# m3_n3682_n4180# 0.06144f
C648 m3_n3794_7580# m3_n3906_7580# 0.06144f
C649 m3_n3682_7580# m3_n3682_7692# 0.06144f
C650 m3_n3906_18892# m3_n3906_19004# 0.06144f
C651 m3_n3682_n18740# m3_n3682_n18628# 0.06144f
C652 m3_n3906_n11684# m3_n3794_n11684# 0.06144f
C653 m3_n3794_14188# m3_n3682_14188# 0.06144f
C654 m3_n3906_14188# m3_n3906_14076# 0.06144f
C655 m3_n3906_n19076# m3_n3906_n18964# 0.06144f
C656 m3_n3682_4332# m3_n3386_n6343# 0.0178f
C657 pincelazo_0/m4_0_1537# x15/X 0.00484f
C658 m3_n3906_20236# m3_n3794_20236# 0.06144f
C659 m3_n3906_n6196# m3_n3906_n6084# 0.06144f
C660 m3_n3906_15980# m3_n3906_15868# 0.06144f
C661 m3_n3794_21244# m3_n3682_21244# 0.06144f
C662 m3_n3906_20572# m3_n3906_20460# 0.06144f
C663 m3_n3794_15980# m3_n3682_15980# 0.06144f
C664 m3_n3682_n6084# m3_n3794_n6084# 0.06144f
C665 m3_n3906_n3508# m3_n3906_n3620# 0.06144f
C666 m3_n3906_13964# m3_n3906_13852# 0.06144f
C667 m3_n3794_13964# m3_n3682_13964# 0.06144f
C668 m3_n3906_n13252# m3_n3906_n13140# 0.06144f
C669 m3_n3794_n4292# m3_n3794_n4404# 0.06144f
C670 m3_n3682_2540# m3_n3682_2652# 0.06144f
C671 m3_n3906_14524# m3_n3906_14412# 0.06144f
C672 m3_n3794_2540# m3_n3906_2540# 0.06144f
C673 m3_n3794_972# m3_n3682_972# 0.06144f
C674 m3_n3386_n6343# x4/A 25.1996f
C675 m3_n3682_3772# m3_n3682_3884# 0.06144f
C676 m3_n3794_5340# m3_n3794_5452# 0.06144f
C677 m3_n3794_18780# m3_n3682_18780# 0.06144f
C678 m3_n3794_n7764# m3_n3794_n7876# 0.06144f
C679 m3_n3794_n18852# m3_n3794_n18740# 0.06144f
C680 m3_n3906_n16164# m3_n3906_n16052# 0.06144f
C681 m3_n3682_12508# m3_n3682_12620# 0.06144f
C682 m3_n3794_12508# m3_n3906_12508# 0.06144f
C683 m3_n3906_n11460# m3_n3906_n11348# 0.06144f
C684 m3_n3794_n9892# m3_n3794_n9780# 0.06144f
C685 m3_n3682_n4516# m3_n3386_n6343# 0.0178f
C686 m3_n3794_22028# m3_n3794_22140# 0.06144f
C687 m3_n3682_n9332# m3_n3682_n9444# 0.06144f
C688 m3_n3682_n10788# m3_n3682_n10676# 0.06144f
C689 m3_n3794_n11348# m3_n3682_n11348# 0.06144f
C690 m3_n3794_n12916# m3_n3682_n12916# 0.06144f
C691 m3_n3794_n17620# m3_n3682_n17620# 0.06144f
C692 m3_n3906_2876# m3_n3794_2876# 0.06144f
C693 m3_n3794_n6868# m3_n3682_n6868# 0.06144f
C694 m3_n3794_2204# m3_n3794_2316# 0.06144f
C695 m3_n3906_19900# m3_n3906_19788# 0.06144f
C696 m3_n3794_n15156# m3_n3794_n15044# 0.06144f
C697 m3_n3906_13628# m3_n3906_13740# 0.06144f
C698 m3_n3682_13740# m3_n3794_13740# 0.06144f
C699 m3_n3906_13068# m3_n3794_13068# 0.06144f
C700 m3_n3906_8700# m3_n3906_8588# 0.06144f
C701 m3_n3906_n4964# m3_n3794_n4964# 0.06144f
C702 m3_n3682_412# m3_n3682_524# 0.06144f
C703 m3_n3906_n13812# m3_n3794_n13812# 0.06144f
C704 m3_n3794_9820# m3_n3794_9708# 0.06144f
C705 m3_n3682_n13700# m3_n3682_n13812# 0.06144f
C706 m3_n3682_n4852# m3_n3682_n4740# 0.06144f
C707 m3_n3794_n4852# m3_n3906_n4852# 0.06144f
C708 m3_n3682_1308# m3_n3386_n6343# 0.0178f
C709 m3_n3682_15868# m3_n3682_15756# 0.06144f
C710 m3_n3794_19228# m3_n3682_19228# 0.06144f
C711 VDPWR x9/A 3.51502f
C712 m3_n3906_11276# m3_n3906_11164# 0.06144f
C713 m3_n3794_11276# m3_n3682_11276# 0.06144f
C714 m3_n3906_n9780# m3_n3794_n9780# 0.06144f
C715 m3_n3906_11276# m3_n3794_11276# 0.06144f
C716 m3_n3682_n9668# m3_n3682_n9780# 0.06144f
C717 m3_n3906_7468# m3_n3906_7580# 0.06144f
C718 m3_n3794_n2164# m3_n3794_n2276# 0.06144f
C719 m3_n3794_11948# m3_n3794_12060# 0.06144f
C720 m3_n3682_n2948# m3_n3682_n2836# 0.06144f
C721 m3_n3906_15532# m3_n3906_15644# 0.06144f
C722 m3_n3906_n14148# m3_n3906_n14036# 0.06144f
C723 m3_n3906_1308# m3_n3794_1308# 0.06144f
C724 m3_n3794_18556# m3_n3682_18556# 0.06144f
C725 m3_n3794_n1716# m3_n3794_n1604# 0.06144f
C726 m3_n3906_n15156# m3_n3906_n15268# 0.06144f
C727 m3_n3794_n4964# m3_n3794_n5076# 0.06144f
C728 m3_n3794_12060# m3_n3794_12172# 0.06144f
C729 m3_n3682_10604# m3_n3794_10604# 0.06144f
C730 m3_n3682_n9892# m3_n3794_n9892# 0.06144f
C731 m3_n3906_n10004# m3_n3906_n9892# 0.06144f
C732 m3_n3906_10492# m3_n3906_10604# 0.06144f
C733 x13/a_109_47# x15/a_109_47# 0.00588f
C734 m3_n3794_19452# m3_n3682_19452# 0.06144f
C735 m3_n3906_n15492# m3_n3794_n15492# 0.06144f
C736 x9/Y x9/A 0.16822f
C737 m3_n3682_n11012# m3_n3682_n10900# 0.06144f
C738 m3_n3794_n11348# m3_n3794_n11236# 0.06144f
C739 m3_n3794_13292# m3_n3794_13404# 0.06144f
C740 m3_n3682_10380# m3_n3682_10268# 0.06144f
C741 m3_n3906_10268# m3_n3794_10268# 0.06144f
C742 m3_n3906_2764# m3_n3906_2876# 0.06144f
C743 m3_n3906_8588# m3_n3794_8588# 0.06144f
C744 m3_n3682_n6196# m3_n3682_n6308# 0.06144f
C745 m3_n3682_2876# m3_n3794_2876# 0.06144f
C746 m3_n3794_10044# m3_n3682_10044# 0.06144f
C747 m3_n3906_n13476# m3_n3794_n13476# 0.06144f
C748 m3_n3682_n2500# m3_n3386_n6343# 0.0178f
C749 m3_n3682_n17284# m3_n3682_n17172# 0.06144f
C750 m3_n3906_9260# m3_n3906_9372# 0.06144f
C751 m3_n3682_n11012# m3_n3682_n11124# 0.06144f
C752 m3_n3906_n11124# m3_n3794_n11124# 0.06144f
C753 m3_n3682_n3844# m3_n3682_n3732# 0.06144f
C754 m3_n3906_n12356# m3_n3906_n12244# 0.06144f
C755 m3_n3906_n5412# m3_n3794_n5412# 0.06144f
C756 m3_n3794_n13252# m3_n3794_n13364# 0.06144f
C757 m3_n3794_2764# m3_n3794_2876# 0.06144f
C758 m3_n3794_n5076# m3_n3682_n5076# 0.06144f
C759 m3_n3906_n11460# m3_n3794_n11460# 0.06144f
C760 m3_n3794_n12020# m3_n3682_n12020# 0.06144f
C761 x15/X x15/a_109_47# 0.0365f
C762 m3_n3794_12396# m3_n3794_12284# 0.06144f
C763 m3_n3794_n5524# m3_n3794_n5636# 0.06144f
C764 m3_n3794_n15380# m3_n3794_n15268# 0.06144f
C765 m3_n3794_n1940# m3_n3906_n1940# 0.06144f
C766 m3_n3682_n1940# m3_n3682_n1828# 0.06144f
C767 m3_n3906_3996# m3_n3794_3996# 0.06144f
C768 m3_n3906_n13028# m3_n3906_n12916# 0.06144f
C769 m3_n3386_n6343# m3_n3682_2764# 0.0178f
C770 m3_n3682_10604# m3_n3682_10716# 0.06144f
C771 m3_n3682_11164# m3_n3682_11276# 0.06144f
C772 m3_n3906_n18404# m3_n3794_n18404# 0.06144f
C773 m3_n3794_11164# m3_n3906_11164# 0.06144f
C774 m3_n3794_18108# m3_n3794_18220# 0.06144f
C775 m3_n3794_11164# m3_n3794_11276# 0.06144f
C776 m3_n3906_n484# m3_n3906_n372# 0.06144f
C777 m3_n3906_n11908# m3_n3906_n11796# 0.06144f
C778 m3_n3794_16764# m3_n3794_16652# 0.06144f
C779 m3_n3682_n1604# m3_n3386_n6343# 0.0178f
C780 m3_n3794_n16724# m3_n3682_n16724# 0.06144f
C781 m3_n3906_n1604# m3_n3906_n1716# 0.06144f
C782 m3_n3794_5900# m3_n3794_5788# 0.06144f
C783 m3_n3794_n1604# m3_n3682_n1604# 0.06144f
C784 x8/A x9/A 2.2648f
C785 m3_n3682_18892# m3_n3682_18780# 0.06144f
C786 m3_n3794_20124# m3_n3682_20124# 0.06144f
C787 m3_n3906_18780# m3_n3794_18780# 0.06144f
C788 m3_n3906_n932# m3_n3906_n820# 0.06144f
C789 m3_n3794_12172# m3_n3794_12284# 0.06144f
C790 m3_n3794_n3620# m3_n3794_n3508# 0.06144f
C791 m3_n3682_3324# m3_n3386_n6343# 0.0178f
C792 m3_n3794_20684# m3_n3794_20796# 0.06144f
C793 m3_n3794_22812# m3_n3906_22812# 0.06144f
C794 m3_n3682_22812# m3_n3682_22924# 0.06144f
C795 m3_n3794_18108# m3_n3906_18108# 0.06144f
C796 m3_n3682_18108# m3_n3682_18220# 0.06144f
C797 x13/X x14/X 0.32134f
C798 m3_n3682_n3844# m3_n3682_n3956# 0.06144f
C799 m3_n3906_n8212# m3_n3794_n8212# 0.06144f
C800 m3_n3682_n8100# m3_n3682_n8212# 0.06144f
C801 m3_n3906_n3956# m3_n3794_n3956# 0.06144f
C802 m3_n3906_20572# m3_n3906_20684# 0.06144f
C803 m3_n3682_20684# m3_n3794_20684# 0.06144f
C804 m3_n3682_n13252# m3_n3794_n13252# 0.06144f
C805 m3_n3906_n10116# m3_n3794_n10116# 0.06144f
C806 m3_n3906_n13364# m3_n3906_n13252# 0.06144f
C807 m3_n3682_n14484# m3_n3682_n14596# 0.06144f
C808 m3_n3794_21468# m3_n3906_21468# 0.06144f
C809 m3_n3794_22476# m3_n3794_22588# 0.06144f
C810 m3_n3682_21468# m3_n3682_21580# 0.06144f
C811 m3_n3906_13292# m3_n3906_13404# 0.06144f
C812 m3_n3906_8252# m3_n3906_8140# 0.06144f
C813 m3_n3906_2092# m3_n3906_1980# 0.06144f
C814 m3_n3906_6012# m3_n3794_6012# 0.06144f
C815 m3_n3682_6124# m3_n3682_6012# 0.06144f
C816 m3_n3682_n18852# m3_n3682_n18740# 0.06144f
C817 m3_n3906_n11236# m3_n3794_n11236# 0.06144f
C818 m3_n3682_7132# m3_n3682_7020# 0.06144f
C819 m3_n3794_12844# m3_n3794_12956# 0.06144f
C820 m3_n3682_636# m3_n3386_n6343# 0.0178f
C821 m3_n3794_n8100# m3_n3794_n8212# 0.06144f
C822 m3_n3682_12284# m3_n3682_12396# 0.06144f
C823 m3_n3794_12284# m3_n3906_12284# 0.06144f
C824 m3_n3794_n8884# m3_n3682_n8884# 0.06144f
C825 m3_n3682_20012# m3_n3682_19900# 0.06144f
C826 m3_n3906_n19188# m3_n3906_n19076# 0.06144f
C827 m3_n3906_19900# m3_n3794_19900# 0.06144f
C828 m3_n3794_17100# m3_n3794_16988# 0.06144f
C829 m3_n3682_524# m3_n3386_n6343# 0.0178f
C830 m3_n3794_n3620# m3_n3794_n3732# 0.06144f
C831 m3_n3794_19676# m3_n3682_19676# 0.06144f
C832 m3_n3906_1420# m3_n3794_1420# 0.06144f
C833 m3_n3682_n6084# m3_n3682_n5972# 0.06144f
C834 m3_n3682_1532# m3_n3682_1420# 0.06144f
C835 m3_n3794_2764# m3_n3906_2764# 0.06144f
C836 m3_n3682_n2276# m3_n3682_n2164# 0.06144f
C837 m3_n3682_2764# m3_n3682_2876# 0.06144f
C838 m3_n3906_n18292# m3_n3794_n18292# 0.06144f
C839 m3_n3682_19564# m3_n3682_19676# 0.06144f
C840 m3_n3906_17548# m3_n3906_17660# 0.06144f
C841 m3_n3794_1868# m3_n3794_1756# 0.06144f
C842 m3_n3906_n2164# m3_n3906_n2052# 0.06144f
C843 m3_n3682_n2052# m3_n3794_n2052# 0.06144f
C844 m3_n3794_22364# m3_n3794_22252# 0.06144f
C845 m3_n3794_n6084# m3_n3794_n6196# 0.06144f
C846 m3_n3906_n8996# m3_n3794_n8996# 0.06144f
C847 m3_n3794_11164# m3_n3682_11164# 0.06144f
C848 m3_n3906_n19748# m3_n3794_n19748# 0.06144f
C849 m3_n3794_2764# m3_n3682_2764# 0.06144f
C850 m3_n3794_18556# m3_n3794_18444# 0.06144f
C851 m3_n3794_10156# m3_n3682_10156# 0.06144f
C852 m3_n3906_9036# m3_n3906_9148# 0.06144f
C853 m3_n3906_10156# m3_n3906_10044# 0.06144f
C854 m3_n3794_n6420# m3_n3682_n6420# 0.06144f
C855 m3_n3794_n18964# m3_n3794_n18852# 0.06144f
C856 m3_n3906_n6196# m3_n3906_n6308# 0.06144f
C857 m3_n3682_5228# m3_n3386_n6343# 0.0178f
C858 m3_n3794_15420# m3_n3682_15420# 0.06144f
C859 m3_n3906_4780# m3_n3906_4668# 0.06144f
C860 m3_n3794_n16948# m3_n3682_n16948# 0.06144f
C861 m3_n3906_n10788# m3_n3906_n10676# 0.06144f
C862 m3_n3794_4220# m3_n3794_4332# 0.06144f
C863 m3_n3794_n13140# m3_n3682_n13140# 0.06144f
C864 m3_n3682_11836# m3_n3682_11948# 0.06144f
C865 m3_n3794_11836# m3_n3906_11836# 0.06144f
C866 m3_n3794_1868# m3_n3794_1980# 0.06144f
C867 m3_n3906_n596# m3_n3906_n484# 0.06144f
C868 m3_n3794_8700# m3_n3682_8700# 0.06144f
C869 m3_n3682_8364# m3_n3682_8476# 0.06144f
C870 m3_n3682_n484# m3_n3794_n484# 0.06144f
C871 m3_n3794_n9668# m3_n3794_n9556# 0.06144f
C872 m3_n3794_n8660# m3_n3682_n8660# 0.06144f
C873 m3_n3906_n10228# m3_n3906_n10116# 0.06144f
C874 m3_n3682_n10116# m3_n3794_n10116# 0.06144f
C875 m3_n3906_n3508# m3_n3906_n3396# 0.06144f
C876 m3_n3682_n3396# m3_n3794_n3396# 0.06144f
C877 m3_n3906_5228# m3_n3794_5228# 0.06144f
C878 m3_n3794_n15828# m3_n3794_n15716# 0.06144f
C879 m3_n3682_5340# m3_n3682_5228# 0.06144f
C880 m3_n3906_13740# m3_n3794_13740# 0.06144f
C881 m3_n3906_5452# m3_n3794_5452# 0.06144f
C882 m3_n3682_5564# m3_n3682_5452# 0.06144f
C883 m3_n3794_13628# m3_n3794_13516# 0.06144f
C884 m3_n3794_6124# m3_n3794_6012# 0.06144f
C885 m3_n3794_n9556# m3_n3906_n9556# 0.06144f
C886 m3_n3682_3212# m3_n3386_n6343# 0.0178f
C887 m3_n3794_n17956# m3_n3794_n18068# 0.06144f
C888 m3_n3682_n9556# m3_n3682_n9444# 0.06144f
C889 m3_n3906_3660# m3_n3906_3772# 0.06144f
C890 m3_n3682_3772# m3_n3794_3772# 0.06144f
C891 m3_n3794_13292# m3_n3794_13180# 0.06144f
C892 m3_n3682_n11572# m3_n3682_n11684# 0.06144f
C893 m3_n3906_n5412# m3_n3906_n5300# 0.06144f
C894 m3_n3794_n12580# m3_n3682_n12580# 0.06144f
C895 x13/X x16/X 0
C896 m3_n3906_20796# m3_n3906_20684# 0.06144f
C897 m3_n3906_n12580# m3_n3906_n12692# 0.06144f
C898 m3_n3906_21580# m3_n3906_21468# 0.06144f
C899 m3_n3794_21580# m3_n3682_21580# 0.06144f
C900 m3_n3906_n19636# m3_n3794_n19636# 0.06144f
C901 m3_n3682_n6084# m3_n3386_n6343# 0.0178f
C902 m3_n3794_2204# m3_n3794_2092# 0.06144f
C903 m3_n3794_n1716# m3_n3682_n1716# 0.06144f
C904 m3_n3794_4108# m3_n3682_4108# 0.06144f
C905 m3_n3682_10940# m3_n3682_10828# 0.06144f
C906 m3_n3794_n5860# m3_n3794_n5972# 0.06144f
C907 m3_n3906_14524# m3_n3794_14524# 0.06144f
C908 m3_n3906_12956# m3_n3906_12844# 0.06144f
C909 m3_n3682_14636# m3_n3682_14524# 0.06144f
C910 m3_n3906_n11684# m3_n3906_n11796# 0.06144f
C911 m3_n3794_n11684# m3_n3682_n11684# 0.06144f
C912 m3_n3906_17996# m3_n3794_17996# 0.06144f
C913 m3_n3794_n19412# m3_n3682_n19412# 0.06144f
C914 m3_n3794_n6868# m3_n3906_n6868# 0.06144f
C915 m3_n3386_n6343# m3_n3682_4780# 0.0178f
C916 m3_n3682_n6868# m3_n3682_n6756# 0.06144f
C917 m3_n3682_n12916# m3_n3682_n13028# 0.06144f
C918 m3_n3794_n18404# m3_n3682_n18404# 0.06144f
C919 m3_n3682_3884# m3_n3386_n6343# 0.0178f
C920 m3_n3682_17884# m3_n3682_17772# 0.06144f
C921 m3_n3906_11612# m3_n3794_11612# 0.06144f
C922 m3_n3682_11724# m3_n3682_11612# 0.06144f
C923 m3_n3794_19116# m3_n3794_19004# 0.06144f
C924 m3_n3906_n932# m3_n3794_n932# 0.06144f
C925 m3_n3682_7020# m3_n3794_7020# 0.06144f
C926 m3_n3906_6908# m3_n3906_7020# 0.06144f
C927 m3_n3682_18556# m3_n3682_18444# 0.06144f
C928 m3_n3682_748# m3_n3386_n6343# 0.0178f
C929 m3_n3906_n12580# m3_n3906_n12468# 0.06144f
C930 m3_n3682_20012# m3_n3682_20124# 0.06144f
C931 m3_n3906_n17284# m3_n3906_n17396# 0.06144f
C932 m3_n3794_n14260# m3_n3906_n14260# 0.06144f
C933 m3_n3682_22812# m3_n3682_22700# 0.06144f
C934 m3_n3682_n14260# m3_n3682_n14148# 0.06144f
C935 m3_n3794_19004# m3_n3906_19004# 0.06144f
C936 m3_n3682_19004# m3_n3682_19116# 0.06144f
C937 VDPWR x4/A 4.44906f
C938 m3_n3906_18444# m3_n3794_18444# 0.06144f
C939 m3_n3794_1644# m3_n3794_1532# 0.06144f
C940 m3_n3682_20572# m3_n3682_20460# 0.06144f
C941 m3_n3794_9260# m3_n3794_9372# 0.06144f
C942 m3_n3794_524# m3_n3682_524# 0.06144f
C943 m3_n3794_14300# m3_n3682_14300# 0.06144f
C944 m3_n3906_16764# m3_n3906_16652# 0.06144f
C945 m3_n3682_n1716# m3_n3682_n1604# 0.06144f
C946 m3_n3906_5676# m3_n3794_5676# 0.06144f
C947 m3_n3682_5788# m3_n3682_5676# 0.06144f
C948 m3_n3794_n1716# m3_n3906_n1716# 0.06144f
C949 m3_n3906_17100# m3_n3906_16988# 0.06144f
C950 m3_n3794_17100# m3_n3682_17100# 0.06144f
C951 m3_n3794_17660# m3_n3906_17660# 0.06144f
C952 m3_n3682_n7428# m3_n3682_n7316# 0.06144f
C953 m3_n3682_17660# m3_n3682_17772# 0.06144f
C954 m3_n3682_n5524# m3_n3682_n5636# 0.06144f
C955 m3_n3794_10940# m3_n3682_10940# 0.06144f
C956 m3_n3794_3996# m3_n3794_3884# 0.06144f
C957 m3_n3682_n10228# m3_n3682_n10340# 0.06144f
C958 m3_n3906_n2836# m3_n3794_n2836# 0.06144f
C959 m3_n3682_n2724# m3_n3682_n2836# 0.06144f
C960 m3_n3682_16652# m3_n3682_16540# 0.06144f
C961 m3_n3682_n16836# m3_n3682_n16724# 0.06144f
C962 m3_n3906_16540# m3_n3794_16540# 0.06144f
C963 m3_n3386_n6343# semilogo_0/m4_0_0# 0.02803f
C964 x9/Y x4/A 3.69429f
C965 m3_n3682_21692# m3_n3682_21580# 0.06144f
C966 m3_n3794_n10004# m3_n3794_n9892# 0.06144f
C967 m3_n3682_4668# m3_n3794_4668# 0.06144f
C968 m3_n3906_4556# m3_n3906_4668# 0.06144f
C969 m3_n3906_10604# m3_n3906_10716# 0.06144f
C970 m3_n3794_5004# m3_n3794_5116# 0.06144f
C971 m3_n3794_n19748# m3_n3682_n19748# 0.06144f
C972 pincelazo_0/m4_0_1537# x4/A 0
C973 m3_n3794_n9668# m3_n3794_n9780# 0.06144f
C974 m3_n3794_n7316# m3_n3794_n7428# 0.06144f
C975 m3_n3906_14412# m3_n3794_14412# 0.06144f
C976 m3_n3682_n18964# m3_n3682_n18852# 0.06144f
C977 m3_n3906_n4068# m3_n3906_n3956# 0.06144f
C978 m3_n3794_5228# m3_n3682_5228# 0.06144f
C979 m3_n3794_n15156# m3_n3906_n15156# 0.06144f
C980 m3_n3906_3100# m3_n3794_3100# 0.06144f
C981 m3_n3682_n15156# m3_n3682_n15044# 0.06144f
C982 m3_n3794_9820# m3_n3682_9820# 0.06144f
C983 m3_n3906_n19300# m3_n3906_n19188# 0.06144f
C984 m3_n3906_n12132# m3_n3906_n12020# 0.06144f
C985 m3_n3794_n7316# m3_n3794_n7204# 0.06144f
C986 m3_n3794_n3172# m3_n3682_n3172# 0.06144f
C987 m3_n3906_n3172# m3_n3906_n3284# 0.06144f
C988 m3_n3794_524# m3_n3794_636# 0.06144f
C989 m3_n3794_n5188# m3_n3794_n5076# 0.06144f
C990 m3_n3906_22812# m3_n3906_22700# 0.06144f
C991 m3_n3794_n9332# m3_n3682_n9332# 0.06144f
C992 m3_n3906_10380# m3_n3906_10268# 0.06144f
C993 m3_n3794_11724# m3_n3794_11836# 0.06144f
C994 m3_n3906_9708# m3_n3906_9820# 0.06144f
C995 m3_n3906_n3844# m3_n3794_n3844# 0.06144f
C996 m3_n3682_10716# m3_n3682_10828# 0.06144f
C997 m3_n3794_n3396# m3_n3794_n3508# 0.06144f
C998 m3_n3794_10380# m3_n3682_10380# 0.06144f
C999 m3_n3794_10716# m3_n3906_10716# 0.06144f
C1000 m3_n3906_n596# m3_n3794_n596# 0.06144f
C1001 m3_n3906_n4292# m3_n3906_n4404# 0.06144f
C1002 m3_n3682_n484# m3_n3682_n596# 0.06144f
C1003 m3_n3794_n4292# m3_n3682_n4292# 0.06144f
C1004 m3_n3906_3100# m3_n3906_3212# 0.06144f
C1005 m3_n3682_n932# m3_n3386_n6343# 0.0178f
C1006 x8/A x4/A 0.22533f
C1007 m3_n3794_12956# m3_n3794_13068# 0.06144f
C1008 m3_n3682_n2388# m3_n3386_n6343# 0.0178f
C1009 m3_n3386_n6343# m3_n3682_2652# 0.0178f
C1010 m3_n3794_n10564# m3_n3682_n10564# 0.06144f
C1011 m3_n3906_n10564# m3_n3906_n10676# 0.06144f
C1012 m3_n3682_1308# m3_n3682_1420# 0.06144f
C1013 m3_n3794_n19076# m3_n3794_n18964# 0.06144f
C1014 m3_n3682_n17956# m3_n3682_n18068# 0.06144f
C1015 m3_n3906_9596# m3_n3906_9484# 0.06144f
C1016 m3_n3682_n4068# m3_n3682_n3956# 0.06144f
C1017 m3_n3682_1644# m3_n3682_1756# 0.06144f
C1018 m3_n3794_1644# m3_n3906_1644# 0.06144f
C1019 m3_n3906_4556# m3_n3906_4444# 0.06144f
C1020 m3_n3794_15308# m3_n3682_15308# 0.06144f
C1021 m3_n3682_n1044# m3_n3386_n6343# 0.0178f
C1022 m3_n3906_15308# m3_n3906_15196# 0.06144f
C1023 m3_n3682_17996# m3_n3682_18108# 0.06144f
C1024 m3_n3794_n11236# m3_n3794_n11124# 0.06144f
C1025 m3_n3794_22140# m3_n3682_22140# 0.06144f
C1026 m3_n3906_n11012# m3_n3794_n11012# 0.06144f
C1027 m3_n3794_n12692# m3_n3794_n12804# 0.06144f
C1028 m3_n3794_n6308# m3_n3794_n6196# 0.06144f
C1029 m3_n3906_17436# m3_n3794_17436# 0.06144f
C1030 m3_n3682_17548# m3_n3682_17436# 0.06144f
C1031 m3_n3794_n1268# m3_n3794_n1380# 0.06144f
C1032 x13/a_109_47# x15/X 0
C1033 m3_n3906_18332# m3_n3906_18444# 0.06144f
C1034 m3_n3682_18444# m3_n3794_18444# 0.06144f
C1035 m3_n3906_22252# m3_n3906_22140# 0.06144f
C1036 m3_n3794_22252# m3_n3682_22252# 0.06144f
C1037 m3_n3682_n10340# m3_n3794_n10340# 0.06144f
C1038 m3_n3906_n10452# m3_n3906_n10340# 0.06144f
C1039 m3_n3794_3212# m3_n3682_3212# 0.06144f
C1040 m3_n3906_21356# m3_n3794_21356# 0.06144f
C1041 m3_n3906_5900# m3_n3906_6012# 0.06144f
C1042 m3_n3794_17884# m3_n3794_17772# 0.06144f
C1043 m3_n3794_15196# m3_n3794_15308# 0.06144f
C1044 m3_n3682_2204# m3_n3386_n6343# 0.0178f
C1045 m3_n3794_n7540# m3_n3682_n7540# 0.06144f
C1046 m3_n3906_2652# m3_n3906_2764# 0.06144f
C1047 m3_n3906_636# m3_n3794_636# 0.06144f
C1048 m3_n3794_13852# m3_n3682_13852# 0.06144f
C1049 m3_n3906_21244# m3_n3906_21132# 0.06144f
C1050 m3_n3794_n9220# m3_n3682_n9220# 0.06144f
C1051 m3_n3906_n2052# m3_n3794_n2052# 0.06144f
C1052 m3_n3906_n9220# m3_n3906_n9332# 0.06144f
C1053 m3_n3682_n2052# m3_n3682_n1940# 0.06144f
C1054 m3_n3682_n15940# m3_n3794_n15940# 0.06144f
C1055 m3_n3906_n16052# m3_n3906_n15940# 0.06144f
C1056 m3_n3682_13404# m3_n3682_13292# 0.06144f
C1057 m3_n3906_1868# m3_n3906_1756# 0.06144f
C1058 m3_n3682_n14148# m3_n3682_n14036# 0.06144f
C1059 m3_n3906_15756# m3_n3794_15756# 0.06144f
C1060 m3_n3906_5004# m3_n3794_5004# 0.06144f
C1061 m3_n3682_5116# m3_n3682_5004# 0.06144f
C1062 m3_n3906_n17284# m3_n3794_n17284# 0.06144f
C1063 m3_n3794_2652# m3_n3794_2764# 0.06144f
C1064 m3_n3906_n7764# m3_n3906_n7876# 0.06144f
C1065 m3_n3906_n9444# m3_n3906_n9332# 0.06144f
C1066 m3_n3794_11612# m3_n3682_11612# 0.06144f
C1067 m3_n3682_5564# m3_n3682_5676# 0.06144f
C1068 m3_n3794_6124# m3_n3682_6124# 0.06144f
C1069 m3_n3906_6124# m3_n3906_6012# 0.06144f
C1070 m3_n3794_17660# m3_n3794_17772# 0.06144f
C1071 m3_n3906_2428# m3_n3794_2428# 0.06144f
C1072 m3_n3682_8588# m3_n3682_8476# 0.06144f
C1073 m3_n3906_8476# m3_n3794_8476# 0.06144f
C1074 m3_n3794_14188# m3_n3794_14300# 0.06144f
C1075 m3_n3682_n2836# m3_n3386_n6343# 0.0178f
C1076 m3_n3906_17884# m3_n3794_17884# 0.06144f
C1077 m3_n3906_10604# m3_n3794_10604# 0.06144f
C1078 m3_n3682_17996# m3_n3682_17884# 0.06144f
C1079 m3_n3682_7132# m3_n3682_7244# 0.06144f
C1080 m3_n3682_16876# m3_n3682_16988# 0.06144f
C1081 m3_n3794_7132# m3_n3906_7132# 0.06144f
C1082 m3_n3682_3996# m3_n3386_n6343# 0.0178f
C1083 m3_n3794_n4292# m3_n3794_n4180# 0.06144f
C1084 m3_n3794_n10452# m3_n3682_n10452# 0.06144f
C1085 m3_n3906_860# m3_n3906_972# 0.06144f
C1086 m3_n3682_n4516# m3_n3682_n4628# 0.06144f
C1087 m3_n3906_n4628# m3_n3794_n4628# 0.06144f
C1088 m3_n3794_n5524# m3_n3906_n5524# 0.06144f
C1089 m3_n3682_n5524# m3_n3682_n5412# 0.06144f
C1090 x4/A x15/a_109_47# 0.01133f
C1091 m3_n3794_16540# m3_n3682_16540# 0.06144f
C1092 m3_n3794_n4516# m3_n3794_n4404# 0.06144f
C1093 m3_n3906_n12580# m3_n3794_n12580# 0.06144f
C1094 m3_n3682_1980# m3_n3794_1980# 0.06144f
C1095 m3_n3906_1868# m3_n3906_1980# 0.06144f
C1096 m3_n3682_5900# m3_n3386_n6343# 0.0178f
C1097 m3_n3794_14972# m3_n3794_15084# 0.06144f
C1098 m3_n3794_n1828# m3_n3682_n1828# 0.06144f
C1099 m3_n3906_n1828# m3_n3906_n1940# 0.06144f
C1100 m3_n3682_3324# m3_n3682_3436# 0.06144f
C1101 m3_n3906_17324# m3_n3794_17324# 0.06144f
C1102 m3_n3794_n16948# m3_n3794_n16836# 0.06144f
C1103 m3_n3794_13964# m3_n3794_14076# 0.06144f
C1104 m3_n3682_13068# m3_n3794_13068# 0.06144f
C1105 m3_n3906_8252# m3_n3794_8252# 0.06144f
C1106 m3_n3906_12956# m3_n3906_13068# 0.06144f
C1107 m3_n3682_8364# m3_n3682_8252# 0.06144f
C1108 m3_n3906_n12804# m3_n3906_n12916# 0.06144f
C1109 m3_n3794_n12804# m3_n3682_n12804# 0.06144f
C1110 m3_n3794_636# m3_n3794_748# 0.06144f
C1111 m3_n3794_n3060# m3_n3794_n3172# 0.06144f
C1112 m3_n3682_n1940# m3_n3386_n6343# 0.0178f
C1113 m3_n3794_8028# m3_n3906_8028# 0.06144f
C1114 m3_n3682_8028# m3_n3682_8140# 0.06144f
C1115 m3_n3906_n17732# m3_n3906_n17620# 0.06144f
C1116 m3_n3682_n4852# m3_n3386_n6343# 0.0178f
C1117 x16/a_109_47# x14/X 0
C1118 m3_n3906_7916# m3_n3906_8028# 0.06144f
C1119 m3_n3906_n11460# m3_n3906_n11572# 0.06144f
C1120 m3_n3794_10604# m3_n3794_10716# 0.06144f
C1121 m3_n3794_n11460# m3_n3682_n11460# 0.06144f
C1122 m3_n3906_n4628# m3_n3906_n4740# 0.06144f
C1123 m3_n3794_n6756# m3_n3794_n6644# 0.06144f
C1124 m3_n3794_21020# m3_n3794_21132# 0.06144f
C1125 m3_n3906_n18628# m3_n3794_n18628# 0.06144f
C1126 m3_n3682_n10676# m3_n3682_n10564# 0.06144f
C1127 m3_n3906_5676# m3_n3906_5788# 0.06144f
C1128 m3_n3906_4220# m3_n3794_4220# 0.06144f
C1129 m3_n3794_16876# m3_n3794_16988# 0.06144f
C1130 m3_n3682_5788# m3_n3794_5788# 0.06144f
C1131 m3_n3794_n10676# m3_n3906_n10676# 0.06144f
C1132 m3_n3794_4780# m3_n3682_4780# 0.06144f
C1133 m3_n3794_n12692# m3_n3906_n12692# 0.06144f
C1134 m3_n3682_n12692# m3_n3682_n12580# 0.06144f
C1135 m3_n3794_n8660# m3_n3794_n8548# 0.06144f
C1136 m3_n3682_n5300# m3_n3682_n5412# 0.06144f
C1137 m3_n3682_4444# m3_n3682_4556# 0.06144f
C1138 m3_n3906_n7652# m3_n3794_n7652# 0.06144f
C1139 m3_n3794_n932# m3_n3794_n1044# 0.06144f
C1140 m3_n3906_n14484# m3_n3906_n14596# 0.06144f
C1141 m3_n3906_n15940# m3_n3794_n15940# 0.06144f
C1142 m3_n3794_3884# m3_n3682_3884# 0.06144f
C1143 m3_n3682_22588# m3_n3682_22700# 0.06144f
C1144 m3_n3794_22588# m3_n3906_22588# 0.06144f
C1145 m3_n3906_6124# m3_n3794_6124# 0.06144f
C1146 m3_n3906_10492# m3_n3906_10380# 0.06144f
C1147 m3_n3794_17324# m3_n3682_17324# 0.06144f
C1148 m3_n3906_17324# m3_n3906_17212# 0.06144f
C1149 m3_n3794_n148# m3_n3794_n36# 0.06144f
C1150 m3_n3682_8924# m3_n3682_9036# 0.06144f
C1151 m3_n3682_188# m3_n3794_188# 0.06144f
C1152 m3_n3906_n6532# m3_n3906_n6420# 0.06144f
C1153 m3_n3794_8924# m3_n3906_8924# 0.06144f
C1154 m3_n3906_76# m3_n3906_188# 0.06144f
C1155 m3_n3682_22700# m3_n3794_22700# 0.06144f
C1156 m3_n3906_22588# m3_n3906_22700# 0.06144f
C1157 m3_n3794_n596# m3_n3794_n708# 0.06144f
C1158 x16/a_109_47# x14/a_109_47# 0.00583f
C1159 m3_n3906_n3620# m3_n3906_n3732# 0.06144f
C1160 m3_n3794_n3620# m3_n3682_n3620# 0.06144f
C1161 m3_n3794_20796# m3_n3682_20796# 0.06144f
C1162 m3_n3794_n820# m3_n3682_n820# 0.06144f
C1163 m3_n3794_10716# m3_n3682_10716# 0.06144f
C1164 m3_n3906_n14596# m3_n3794_n14596# 0.06144f
C1165 m3_n3682_n3844# m3_n3386_n6343# 0.0178f
C1166 m3_n3794_748# m3_n3682_748# 0.06144f
C1167 m3_n3794_20460# m3_n3794_20348# 0.06144f
C1168 m3_n3794_12508# m3_n3794_12620# 0.06144f
C1169 m3_n3794_n3284# m3_n3794_n3172# 0.06144f
C1170 m3_n3682_20684# m3_n3682_20796# 0.06144f
C1171 m3_n3906_n17508# m3_n3906_n17620# 0.06144f
C1172 m3_n3794_9036# m3_n3794_9148# 0.06144f
C1173 m3_n3794_n8100# m3_n3682_n8100# 0.06144f
C1174 m3_n3682_n19076# m3_n3682_n18964# 0.06144f
C1175 m3_n3906_n8100# m3_n3906_n8212# 0.06144f
C1176 m3_n3906_8140# m3_n3906_8028# 0.06144f
C1177 m3_n3794_8140# m3_n3682_8140# 0.06144f
C1178 m3_n3682_8364# m3_n3794_8364# 0.06144f
C1179 m3_n3906_8252# m3_n3906_8364# 0.06144f
C1180 m3_n3906_6796# m3_n3794_6796# 0.06144f
C1181 m3_n3794_4892# m3_n3794_4780# 0.06144f
C1182 m3_n3906_n19412# m3_n3906_n19300# 0.06144f
C1183 m3_n3682_11164# m3_n3682_11052# 0.06144f
C1184 m3_n3906_n17396# m3_n3794_n17396# 0.06144f
C1185 m3_n3682_2316# m3_n3682_2428# 0.06144f
C1186 m3_n3794_2316# m3_n3906_2316# 0.06144f
C1187 m3_n3794_1420# m3_n3682_1420# 0.06144f
C1188 m3_n3906_18668# m3_n3794_18668# 0.06144f
C1189 m3_n3682_10044# m3_n3682_9932# 0.06144f
C1190 m3_n3794_2988# m3_n3794_2876# 0.06144f
C1191 m3_n3906_n18516# m3_n3794_n18516# 0.06144f
C1192 m3_n3906_n8100# m3_n3794_n8100# 0.06144f
C1193 m3_n3682_n36# m3_n3794_n36# 0.06144f
C1194 m3_n3906_n148# m3_n3906_n36# 0.06144f
C1195 m3_n3794_3436# m3_n3682_3436# 0.06144f
C1196 m3_n3794_n8660# m3_n3906_n8660# 0.06144f
C1197 m3_n3682_n8660# m3_n3682_n8548# 0.06144f
C1198 m3_n3682_n16164# m3_n3794_n16164# 0.06144f
C1199 m3_n3906_n16276# m3_n3906_n16164# 0.06144f
C1200 m3_n3682_2988# m3_n3386_n6343# 0.0178f
C1201 m3_n3906_n19972# m3_n3794_n19972# 0.06144f
C1202 m3_n3906_4332# m3_n3794_4332# 0.06144f
C1203 m3_n3794_n12244# m3_n3794_n12132# 0.06144f
C1204 m3_n3682_4444# m3_n3682_4332# 0.06144f
C1205 m3_n3682_n8324# m3_n3682_n8212# 0.06144f
C1206 m3_n3682_n6532# m3_n3682_n6644# 0.06144f
C1207 m3_n3906_n6644# m3_n3794_n6644# 0.06144f
C1208 m3_n3682_13292# m3_n3682_13180# 0.06144f
C1209 m3_n3906_13180# m3_n3794_13180# 0.06144f
C1210 m3_n3794_n19188# m3_n3794_n19076# 0.06144f
C1211 m3_n3794_n7764# m3_n3794_n7652# 0.06144f
C1212 m3_n3682_11276# m3_n3682_11388# 0.06144f
C1213 m3_n3906_7132# m3_n3906_7020# 0.06144f
C1214 m3_n3682_n15492# m3_n3682_n15380# 0.06144f
C1215 m3_n3794_11276# m3_n3794_11388# 0.06144f
C1216 m3_n3906_21804# m3_n3794_21804# 0.06144f
C1217 m3_n3794_n18292# m3_n3682_n18292# 0.06144f
C1218 m3_n3794_7356# m3_n3794_7244# 0.06144f
C1219 m3_n3906_18892# m3_n3794_18892# 0.06144f
C1220 m3_n3906_n4068# m3_n3906_n4180# 0.06144f
C1221 m3_n3794_n4068# m3_n3682_n4068# 0.06144f
C1222 x16/X x16/a_109_47# 0.03661f
C1223 m3_n3906_4892# m3_n3794_4892# 0.06144f
C1224 m3_n3794_n10900# m3_n3682_n10900# 0.06144f
C1225 m3_n3682_n2276# m3_n3386_n6343# 0.0178f
C1226 m3_n3906_21916# m3_n3794_21916# 0.06144f
C1227 m3_n3682_22028# m3_n3682_21916# 0.06144f
C1228 m3_n3682_188# m3_n3682_300# 0.06144f
C1229 m3_n3794_n17284# m3_n3682_n17284# 0.06144f
C1230 m3_n3906_22364# m3_n3906_22252# 0.06144f
C1231 m3_n3682_14860# m3_n3682_14972# 0.06144f
C1232 pincelazo_0/m4_3975_2025# pincelazo_0/m4_3975_1537# 0.13385f
C1233 m3_n3906_n2948# m3_n3906_n3060# 0.06144f
C1234 m3_n3794_n2948# m3_n3682_n2948# 0.06144f
C1235 m3_n3906_19564# m3_n3906_19676# 0.06144f
C1236 m3_n3682_n2164# m3_n3682_n2052# 0.06144f
C1237 m3_n3794_n2164# m3_n3906_n2164# 0.06144f
C1238 m3_n3906_14188# m3_n3794_14188# 0.06144f
C1239 m3_n3682_n3060# m3_n3682_n2948# 0.06144f
C1240 m3_n3794_1084# m3_n3794_1196# 0.06144f
C1241 m3_n3794_n3060# m3_n3906_n3060# 0.06144f
C1242 m3_n3906_n6084# m3_n3906_n5972# 0.06144f
C1243 m3_n3906_20124# m3_n3906_20236# 0.06144f
C1244 m3_n3682_n3508# m3_n3386_n6343# 0.0178f
C1245 m3_n3794_1980# m3_n3794_2092# 0.06144f
C1246 m3_n3682_20236# m3_n3794_20236# 0.06144f
C1247 m3_n3682_11052# m3_n3682_10940# 0.06144f
C1248 m3_n3906_10940# m3_n3794_10940# 0.06144f
C1249 m3_n3906_16428# m3_n3794_16428# 0.06144f
C1250 m3_n3794_14524# m3_n3794_14412# 0.06144f
C1251 m3_n3794_n16948# m3_n3794_n17060# 0.06144f
C1252 m3_n3682_6124# m3_n3682_6236# 0.06144f
C1253 m3_n3906_n14148# m3_n3794_n14148# 0.06144f
C1254 m3_n3682_11724# m3_n3794_11724# 0.06144f
C1255 m3_n3906_11612# m3_n3906_11724# 0.06144f
C1256 m3_n3794_n11124# m3_n3682_n11124# 0.06144f
C1257 m3_n3906_n19860# m3_n3794_n19860# 0.06144f
C1258 m3_n3794_n16164# m3_n3794_n16052# 0.06144f
C1259 pincelazo_0/m4_3975_2025# pincelazo_0/m4_0_1537# 0.34686f
C1260 m3_n3682_2988# m3_n3682_2876# 0.06144f
C1261 m3_n3906_n5188# m3_n3794_n5188# 0.06144f
C1262 m3_n3906_748# m3_n3906_636# 0.06144f
C1263 m3_n3794_17324# m3_n3794_17212# 0.06144f
C1264 m3_n3794_860# m3_n3794_748# 0.06144f
C1265 m3_n3906_20796# m3_n3794_20796# 0.06144f
C1266 m3_n3682_20908# m3_n3682_20796# 0.06144f
C1267 m3_n3682_n4740# m3_n3386_n6343# 0.0178f
C1268 m3_n3906_8924# m3_n3906_8812# 0.06144f
C1269 m3_n3794_n9444# m3_n3682_n9444# 0.06144f
C1270 m3_n3682_n9108# m3_n3682_n9220# 0.06144f
C1271 m3_n3906_n9444# m3_n3906_n9556# 0.06144f
C1272 m3_n3794_n11908# m3_n3682_n11908# 0.06144f
C1273 m3_n3794_n13028# m3_n3794_n12916# 0.06144f
C1274 m3_n3906_n11908# m3_n3906_n12020# 0.06144f
C1275 m3_n3906_16876# m3_n3906_16988# 0.06144f
C1276 m3_n3682_n6532# m3_n3794_n6532# 0.06144f
C1277 m3_n3906_n3396# m3_n3906_n3284# 0.06144f
C1278 m3_n3906_n6644# m3_n3906_n6532# 0.06144f
C1279 m3_n3794_n10788# m3_n3794_n10900# 0.06144f
C1280 m3_n3682_13516# m3_n3682_13628# 0.06144f
C1281 m3_n3386_n6343# m3_n3682_n3732# 0.0178f
C1282 m3_n3386_n6343# m3_n3682_n4404# 0.0178f
C1283 m3_n3794_n7764# m3_n3682_n7764# 0.06144f
C1284 m3_n3682_3996# m3_n3682_4108# 0.06144f
C1285 m3_n3906_7692# m3_n3794_7692# 0.06144f
C1286 x4/A ardilla_0/m3_0_2333# 0.02603f
C1287 x9/Y semilogo_0/m4_0_0# 0.17615f
C1288 m3_n3794_n19636# m3_n3682_n19636# 0.06144f
C1289 m3_n3794_6348# m3_n3682_6348# 0.06144f
C1290 m3_n3906_6348# m3_n3906_6236# 0.06144f
C1291 m3_n3794_n18628# m3_n3682_n18628# 0.06144f
C1292 m3_n3682_14972# m3_n3682_15084# 0.06144f
C1293 m3_n3794_14972# m3_n3906_14972# 0.06144f
C1294 m3_n3682_n2164# m3_n3386_n6343# 0.0178f
C1295 m3_n3906_n17956# m3_n3794_n17956# 0.06144f
C1296 m3_n3906_n2724# m3_n3906_n2612# 0.06144f
C1297 m3_n3682_5116# m3_n3386_n6343# 0.0178f
C1298 m3_n3906_n8884# m3_n3906_n8996# 0.06144f
C1299 m3_n3906_17212# m3_n3794_17212# 0.06144f
C1300 m3_n3682_17324# m3_n3682_17212# 0.06144f
C1301 m3_n3682_3548# m3_n3386_n6343# 0.0178f
C1302 m3_n3906_n17956# m3_n3906_n17844# 0.06144f
C1303 m3_n3906_20460# m3_n3906_20348# 0.06144f
C1304 m3_n3682_n1156# m3_n3682_n1044# 0.06144f
C1305 m3_n3794_20460# m3_n3682_20460# 0.06144f
C1306 m3_n3906_n10004# m3_n3906_n10116# 0.06144f
C1307 m3_n3906_5564# m3_n3794_5564# 0.06144f
C1308 m3_n3906_n11012# m3_n3906_n10900# 0.06144f
C1309 m3_n3682_n8660# m3_n3682_n8772# 0.06144f
C1310 m3_n3794_n2052# m3_n3794_n1940# 0.06144f
C1311 m3_n3682_n2948# m3_n3386_n6343# 0.0178f
C1312 m3_n3682_860# m3_n3682_748# 0.06144f
C1313 m3_n3906_21020# m3_n3906_21132# 0.06144f
C1314 m3_n3682_21132# m3_n3794_21132# 0.06144f
C1315 m3_n3906_748# m3_n3794_748# 0.06144f
C1316 m3_n3794_9820# m3_n3906_9820# 0.06144f
C1317 m3_n3682_2540# m3_n3386_n6343# 0.0178f
C1318 m3_n3794_1644# m3_n3794_1756# 0.06144f
C1319 m3_n3682_9820# m3_n3682_9932# 0.06144f
C1320 m3_n3682_9708# m3_n3682_9596# 0.06144f
C1321 m3_n3906_9596# m3_n3794_9596# 0.06144f
C1322 m3_n3682_n3956# m3_n3386_n6343# 0.0178f
C1323 m3_n3682_16204# m3_n3794_16204# 0.06144f
C1324 m3_n3906_16092# m3_n3906_16204# 0.06144f
C1325 m3_n3794_6124# m3_n3794_6236# 0.06144f
C1326 m3_n3386_n6343# m3_n3682_n5636# 0.0178f
C1327 m3_n3906_n10788# m3_n3794_n10788# 0.06144f
C1328 m3_n3682_n5524# m3_n3386_n6343# 0.0178f
C1329 m3_n3794_12620# m3_n3682_12620# 0.06144f
C1330 m3_n3906_12620# m3_n3906_12508# 0.06144f
C1331 m3_n3906_2652# m3_n3794_2652# 0.06144f
C1332 m3_n3386_n6343# m3_n3682_n1492# 0.0178f
C1333 m3_n3682_10380# m3_n3682_10492# 0.06144f
C1334 m3_n3794_n17284# m3_n3794_n17396# 0.06144f
C1335 m3_n3386_n6343# m3_n3682_n1828# 0.0178f
C1336 m3_n3682_n820# m3_n3682_n932# 0.06144f
C1337 x14/X VDPWR 0.07374f
C1338 m3_n3906_3324# m3_n3906_3212# 0.06144f
C1339 m3_n3794_3324# m3_n3682_3324# 0.06144f
C1340 m3_n3794_n13588# m3_n3794_n13700# 0.06144f
C1341 m3_n3682_188# m3_n3386_n6343# 0.0178f
C1342 m3_n3794_n8324# m3_n3794_n8212# 0.06144f
C1343 m3_n3682_3660# m3_n3682_3548# 0.06144f
C1344 m3_n3906_n4964# m3_n3906_n4852# 0.06144f
C1345 m3_n3682_14076# m3_n3682_14188# 0.06144f
C1346 m3_n3794_14076# m3_n3906_14076# 0.06144f
C1347 m3_n3794_n2388# m3_n3682_n2388# 0.06144f
C1348 m3_n3682_22588# m3_n3682_22476# 0.06144f
C1349 m3_n3906_12732# m3_n3906_12620# 0.06144f
C1350 m3_n3794_9932# m3_n3794_10044# 0.06144f
C1351 m3_n3794_n12356# m3_n3794_n12244# 0.06144f
C1352 m3_n3794_17436# m3_n3682_17436# 0.06144f
C1353 m3_n3794_12956# m3_n3682_12956# 0.06144f
C1354 m3_n3682_n14260# m3_n3682_n14372# 0.06144f
C1355 m3_n3682_n7092# m3_n3682_n6980# 0.06144f
C1356 m3_n3794_n7092# m3_n3906_n7092# 0.06144f
C1357 m3_n3794_n19972# m3_n3682_n19972# 0.06144f
C1358 m3_n3906_1532# m3_n3794_1532# 0.06144f
C1359 m3_n3906_860# m3_n3794_860# 0.06144f
C1360 m3_n3682_16092# m3_n3682_16204# 0.06144f
C1361 m3_n3794_16092# m3_n3906_16092# 0.06144f
C1362 m3_n3794_n5524# m3_n3794_n5412# 0.06144f
C1363 m3_n3682_6908# m3_n3682_6796# 0.06144f
C1364 m3_n3794_n12132# m3_n3794_n12020# 0.06144f
C1365 m3_n3906_18332# m3_n3906_18220# 0.06144f
C1366 m3_n3906_6348# m3_n3794_6348# 0.06144f
C1367 m3_n3682_19788# m3_n3794_19788# 0.06144f
C1368 m3_n3906_n1492# m3_n3794_n1492# 0.06144f
C1369 m3_n3682_n1380# m3_n3682_n1492# 0.06144f
C1370 m3_n3906_19676# m3_n3906_19788# 0.06144f
C1371 m3_n3682_n19188# m3_n3682_n19076# 0.06144f
C1372 m3_n3682_n15940# m3_n3682_n15828# 0.06144f
C1373 VDPWR x14/a_109_47# 0.03075f
C1374 m3_n3682_n5300# m3_n3386_n6343# 0.0178f
C1375 m3_n3906_9596# m3_n3906_9708# 0.06144f
C1376 m3_n3682_9708# m3_n3794_9708# 0.06144f
C1377 m3_n3794_n12692# m3_n3794_n12580# 0.06144f
C1378 m3_n3906_10156# m3_n3906_10268# 0.06144f
C1379 m3_n3906_11052# m3_n3906_11164# 0.06144f
C1380 m3_n3794_n1044# m3_n3682_n1044# 0.06144f
C1381 m3_n3906_n19524# m3_n3906_n19412# 0.06144f
C1382 m3_n3794_412# m3_n3794_300# 0.06144f
C1383 m3_n3682_1980# m3_n3386_n6343# 0.0178f
C1384 m3_n3794_3772# m3_n3794_3884# 0.06144f
C1385 m3_n3794_n11796# m3_n3794_n11908# 0.06144f
C1386 m3_n3794_5452# m3_n3682_5452# 0.06144f
C1387 m3_n3906_22924# m3_n3794_22924# 0.06144f
C1388 m3_n3794_n13588# m3_n3906_n13588# 0.06144f
C1389 m3_n3682_n13588# m3_n3682_n13476# 0.06144f
C1390 m3_n3906_n14932# m3_n3906_n15044# 0.06144f
C1391 m3_n3906_n15268# m3_n3794_n15268# 0.06144f
C1392 m3_n3794_n13364# m3_n3682_n13364# 0.06144f
C1393 m3_n3906_188# m3_n3906_300# 0.06144f
C1394 m3_n3794_8700# m3_n3794_8812# 0.06144f
C1395 x13/a_109_47# x4/A 0.00209f
C1396 m3_n3682_17548# m3_n3794_17548# 0.06144f
C1397 m3_n3906_17436# m3_n3906_17548# 0.06144f
C1398 m3_n3794_18444# m3_n3794_18332# 0.06144f
C1399 m3_n3906_n16836# m3_n3794_n16836# 0.06144f
C1400 m3_n3794_n5412# m3_n3794_n5300# 0.06144f
C1401 m3_n3682_n14820# m3_n3794_n14820# 0.06144f
C1402 m3_n3794_n15492# m3_n3794_n15604# 0.06144f
C1403 m3_n3906_n14932# m3_n3906_n14820# 0.06144f
C1404 m3_n3682_13852# m3_n3682_13964# 0.06144f
C1405 m3_n3794_13852# m3_n3906_13852# 0.06144f
C1406 m3_n3794_10268# m3_n3682_10268# 0.06144f
C1407 m3_n3794_n19300# m3_n3794_n19188# 0.06144f
C1408 m3_n3906_n14708# m3_n3906_n14820# 0.06144f
C1409 m3_n3682_n7092# m3_n3682_n7204# 0.06144f
C1410 m3_n3682_n4068# m3_n3386_n6343# 0.0178f
C1411 m3_n3794_20908# m3_n3794_20796# 0.06144f
C1412 m3_n3682_n16948# m3_n3682_n17060# 0.06144f
C1413 m3_n3794_6908# m3_n3682_6908# 0.06144f
C1414 m3_n3906_n1156# m3_n3794_n1156# 0.06144f
C1415 m3_n3906_12060# m3_n3794_12060# 0.06144f
C1416 m3_n3682_12172# m3_n3682_12060# 0.06144f
C1417 m3_n3794_11724# m3_n3794_11612# 0.06144f
C1418 m3_n3794_860# m3_n3682_860# 0.06144f
C1419 m3_n3906_860# m3_n3906_748# 0.06144f
C1420 m3_n3794_17212# m3_n3682_17212# 0.06144f
C1421 m3_n3906_8364# m3_n3906_8476# 0.06144f
C1422 m3_n3906_5228# m3_n3906_5340# 0.06144f
C1423 m3_n3682_5340# m3_n3794_5340# 0.06144f
C1424 x4/A x15/X 0
C1425 m3_n3906_n5860# m3_n3794_n5860# 0.06144f
C1426 m3_n3906_n708# m3_n3906_n820# 0.06144f
C1427 m3_n3794_9148# m3_n3906_9148# 0.06144f
C1428 m3_n3794_n708# m3_n3682_n708# 0.06144f
C1429 m3_n3682_9148# m3_n3682_9260# 0.06144f
C1430 m3_n3794_n16164# m3_n3794_n16276# 0.06144f
C1431 m3_n3682_21356# m3_n3794_21356# 0.06144f
C1432 m3_n3906_21244# m3_n3906_21356# 0.06144f
C1433 m3_n3794_76# m3_n3794_188# 0.06144f
C1434 m3_n3794_3324# m3_n3794_3436# 0.06144f
C1435 m3_n3794_n13812# m3_n3794_n13924# 0.06144f
C1436 m3_n3906_4668# m3_n3794_4668# 0.06144f
C1437 m3_n3794_n5748# m3_n3794_n5860# 0.06144f
C1438 m3_n3794_n4628# m3_n3682_n4628# 0.06144f
C1439 m3_n3906_n18180# m3_n3794_n18180# 0.06144f
C1440 x16/X VDPWR 0.07647f
C1441 m3_n3906_n8548# m3_n3794_n8548# 0.06144f
C1442 m3_n3682_n6420# m3_n3682_n6308# 0.06144f
C1443 m3_n3794_n6420# m3_n3906_n6420# 0.06144f
C1444 m3_n3682_3772# m3_n3386_n6343# 0.0178f
C1445 m3_n3794_19116# m3_n3794_19228# 0.06144f
C1446 m3_n3794_n9556# m3_n3682_n9556# 0.06144f
C1447 m3_n3794_6460# m3_n3682_6460# 0.06144f
C1448 m3_n3906_22028# m3_n3906_22140# 0.06144f
C1449 m3_n3682_n13252# m3_n3682_n13364# 0.06144f
C1450 m3_n3794_n5748# m3_n3682_n5748# 0.06144f
C1451 m3_n3682_n5860# m3_n3682_n5972# 0.06144f
C1452 m3_n3906_n5972# m3_n3794_n5972# 0.06144f
C1453 m3_n3906_n13364# m3_n3794_n13364# 0.06144f
C1454 m3_n3906_n6196# m3_n3794_n6196# 0.06144f
C1455 m3_n3794_n3844# m3_n3794_n3732# 0.06144f
C1456 m3_n3682_n6084# m3_n3682_n6196# 0.06144f
C1457 m3_n3682_n4068# m3_n3682_n4180# 0.06144f
C1458 m3_n3682_n2500# m3_n3794_n2500# 0.06144f
C1459 m3_n3906_n4180# m3_n3794_n4180# 0.06144f
C1460 m3_n3794_11052# m3_n3794_11164# 0.06144f
C1461 m3_n3682_16652# m3_n3682_16764# 0.06144f
C1462 m3_n3906_n2612# m3_n3906_n2500# 0.06144f
C1463 m3_n3906_13516# m3_n3794_13516# 0.06144f
C1464 m3_n3794_n15828# m3_n3794_n15940# 0.06144f
C1465 m3_n3906_1644# m3_n3906_1532# 0.06144f
C1466 m3_n3682_19228# m3_n3682_19116# 0.06144f
C1467 m3_n3794_n3284# m3_n3794_n3396# 0.06144f
C1468 m3_n3794_20236# m3_n3794_20348# 0.06144f
C1469 m3_n3794_n1156# m3_n3794_n1268# 0.06144f
C1470 x8/A x14/a_109_47# 0
C1471 m3_n3794_n17956# m3_n3682_n17956# 0.06144f
C1472 m3_n3682_n13924# m3_n3682_n13812# 0.06144f
C1473 m3_n3906_n1156# m3_n3906_n1044# 0.06144f
C1474 m3_n3906_12956# m3_n3794_12956# 0.06144f
C1475 m3_n3682_13068# m3_n3682_12956# 0.06144f
C1476 m3_n3794_n4628# m3_n3794_n4740# 0.06144f
C1477 m3_n3794_n372# m3_n3682_n372# 0.06144f
C1478 m3_n3682_16204# m3_n3682_16316# 0.06144f
C1479 m3_n3906_3660# m3_n3794_3660# 0.06144f
C1480 m3_n3682_3772# m3_n3682_3660# 0.06144f
C1481 m3_n3682_300# m3_n3682_412# 0.06144f
C1482 m3_n3682_4220# m3_n3682_4332# 0.06144f
C1483 m3_n3794_300# m3_n3906_300# 0.06144f
C1484 m3_n3794_n7092# m3_n3682_n7092# 0.06144f
C1485 m3_n3794_n10228# m3_n3794_n10116# 0.06144f
C1486 m3_n3794_15644# m3_n3794_15756# 0.06144f
C1487 m3_n3906_2988# m3_n3906_2876# 0.06144f
C1488 m3_n3906_10492# m3_n3794_10492# 0.06144f
C1489 m3_n3682_10604# m3_n3682_10492# 0.06144f
C1490 m3_n3906_2204# m3_n3794_2204# 0.06144f
C1491 m3_n3682_12172# m3_n3682_12284# 0.06144f
C1492 m3_n3386_n6343# m3_n3682_n5412# 0.0178f
C1493 m3_n3794_1084# m3_n3794_972# 0.06144f
C1494 m3_n3794_9932# m3_n3794_9820# 0.06144f
C1495 m3_n3794_6684# m3_n3794_6796# 0.06144f
C1496 m3_n3794_14748# m3_n3794_14860# 0.06144f
C1497 m3_n3906_n4516# m3_n3906_n4404# 0.06144f
C1498 m3_n3794_n1268# m3_n3682_n1268# 0.06144f
C1499 m3_n3682_5004# m3_n3386_n6343# 0.0178f
C1500 m3_n3794_n3844# m3_n3794_n3956# 0.06144f
C1501 m3_n3794_n2164# m3_n3794_n2052# 0.06144f
C1502 m3_n3906_n2948# m3_n3906_n2836# 0.06144f
C1503 m3_n3682_n4852# m3_n3682_n4964# 0.06144f
C1504 m3_n3682_n17284# m3_n3682_n17396# 0.06144f
C1505 m3_n3906_n8660# m3_n3906_n8548# 0.06144f
C1506 m3_n3682_13628# m3_n3682_13740# 0.06144f
C1507 m3_n3682_n8548# m3_n3794_n8548# 0.06144f
C1508 m3_n3794_22812# m3_n3682_22812# 0.06144f
C1509 m3_n3794_13628# m3_n3906_13628# 0.06144f
C1510 m3_n3906_7244# m3_n3906_7356# 0.06144f
C1511 m3_n3906_n4740# m3_n3794_n4740# 0.06144f
C1512 m3_n3906_18332# m3_n3794_18332# 0.06144f
C1513 m3_n3794_6236# m3_n3682_6236# 0.06144f
C1514 m3_n3682_18444# m3_n3682_18332# 0.06144f
C1515 m3_n3906_4220# m3_n3906_4332# 0.06144f
C1516 m3_n3906_8476# m3_n3906_8588# 0.06144f
C1517 m3_n3682_8588# m3_n3794_8588# 0.06144f
C1518 m3_n3794_n2836# m3_n3682_n2836# 0.06144f
C1519 m3_n3906_12396# m3_n3794_12396# 0.06144f
C1520 m3_n3682_20908# m3_n3794_20908# 0.06144f
C1521 m3_n3682_19788# m3_n3682_19900# 0.06144f
C1522 m3_n3906_20796# m3_n3906_20908# 0.06144f
C1523 m3_n3906_6460# m3_n3794_6460# 0.06144f
C1524 m3_n3682_6572# m3_n3682_6460# 0.06144f
C1525 m3_n3794_11052# m3_n3794_10940# 0.06144f
C1526 m3_n3682_n5860# m3_n3386_n6343# 0.0178f
C1527 m3_n3682_8252# m3_n3682_8140# 0.06144f
C1528 m3_n3906_13292# m3_n3794_13292# 0.06144f
C1529 x16/X x8/A 0
C1530 m3_n3794_19564# m3_n3794_19676# 0.06144f
C1531 m3_n3682_n1716# m3_n3682_n1828# 0.06144f
C1532 m3_n3906_n14372# m3_n3906_n14260# 0.06144f
C1533 m3_n3906_n18852# m3_n3794_n18852# 0.06144f
C1534 m3_n3906_19564# m3_n3906_19452# 0.06144f
C1535 m3_n3794_19564# m3_n3682_19564# 0.06144f
C1536 m3_n3794_n8660# m3_n3794_n8772# 0.06144f
C1537 m3_n3906_n15604# m3_n3906_n15492# 0.06144f
C1538 m3_n3794_n11796# m3_n3794_n11684# 0.06144f
C1539 m3_n3794_17996# m3_n3794_18108# 0.06144f
C1540 m3_n3682_n15492# m3_n3794_n15492# 0.06144f
C1541 m3_n3682_17660# m3_n3682_17548# 0.06144f
C1542 m3_n3794_14524# m3_n3682_14524# 0.06144f
C1543 m3_n3794_2540# m3_n3794_2428# 0.06144f
C1544 m3_n3682_1196# m3_n3386_n6343# 0.0178f
C1545 m3_n3794_22028# m3_n3794_21916# 0.06144f
C1546 m3_n3794_n17732# m3_n3794_n17620# 0.06144f
C1547 m3_n3794_n13028# m3_n3682_n13028# 0.06144f
C1548 m3_n3906_n13028# m3_n3906_n13140# 0.06144f
C1549 m3_n3906_7132# m3_n3906_7244# 0.06144f
C1550 m3_n3682_7244# m3_n3794_7244# 0.06144f
C1551 m3_n3794_n5300# m3_n3906_n5300# 0.06144f
C1552 m3_n3682_n5300# m3_n3682_n5188# 0.06144f
C1553 x9/A x4/A 0.04922f
C1554 m3_n3906_4444# m3_n3794_4444# 0.06144f
C1555 m3_n3794_20572# m3_n3682_20572# 0.06144f
C1556 m3_n3682_n10228# m3_n3682_n10116# 0.06144f
C1557 m3_n3794_n10228# m3_n3906_n10228# 0.06144f
C1558 m3_n3794_1196# m3_n3794_1308# 0.06144f
C1559 m3_n3794_5900# m3_n3682_5900# 0.06144f
C1560 m3_n3906_11948# m3_n3794_11948# 0.06144f
C1561 m3_n3906_14300# m3_n3906_14412# 0.06144f
C1562 m3_n3682_14412# m3_n3794_14412# 0.06144f
C1563 m3_n3794_5228# m3_n3794_5340# 0.06144f
C1564 m3_n3682_n36# m3_n3682_76# 0.06144f
C1565 m3_n3794_19004# m3_n3794_18892# 0.06144f
C1566 m3_n3682_n6532# m3_n3682_n6420# 0.06144f
C1567 m3_n3794_13180# m3_n3794_13068# 0.06144f
C1568 m3_n3682_n19300# m3_n3682_n19188# 0.06144f
C1569 m3_n3794_3548# m3_n3794_3660# 0.06144f
C1570 m3_n3794_n10004# m3_n3794_n10116# 0.06144f
C1571 m3_n3794_12396# m3_n3682_12396# 0.06144f
C1572 m3_n3906_12396# m3_n3906_12284# 0.06144f
C1573 m3_n3906_4108# m3_n3906_3996# 0.06144f
C1574 m3_n3906_n19636# m3_n3906_n19524# 0.06144f
C1575 m3_n3794_n1940# m3_n3682_n1940# 0.06144f
C1576 m3_n3794_n4852# m3_n3682_n4852# 0.06144f
C1577 m3_n3682_n2724# m3_n3386_n6343# 0.0178f
C1578 m3_n3794_16428# m3_n3682_16428# 0.06144f
C1579 m3_n3906_16428# m3_n3906_16316# 0.06144f
C1580 m3_n3906_12172# m3_n3794_12172# 0.06144f
C1581 m3_n3906_5900# m3_n3906_5788# 0.06144f
C1582 m3_n3906_n18740# m3_n3794_n18740# 0.06144f
C1583 m3_n3682_412# m3_n3386_n6343# 0.0178f
C1584 m3_n3794_n13252# m3_n3794_n13140# 0.06144f
C1585 m3_n3906_n17172# m3_n3906_n17060# 0.06144f
C1586 m3_n3682_18668# m3_n3794_18668# 0.06144f
C1587 m3_n3906_18556# m3_n3906_18668# 0.06144f
C1588 m3_n3682_1644# m3_n3682_1532# 0.06144f
C1589 m3_n3906_n13812# m3_n3906_n13924# 0.06144f
C1590 m3_n3794_n5748# m3_n3794_n5636# 0.06144f
C1591 m3_n3906_4556# m3_n3794_4556# 0.06144f
C1592 m3_n3794_n17508# m3_n3794_n17620# 0.06144f
C1593 m3_n3794_n14260# m3_n3682_n14260# 0.06144f
C1594 m3_n3682_4668# m3_n3682_4556# 0.06144f
C1595 m3_n3906_n8996# m3_n3906_n9108# 0.06144f
C1596 m3_n3794_n8996# m3_n3682_n8996# 0.06144f
C1597 m3_n3906_18220# m3_n3794_18220# 0.06144f
C1598 m3_n3682_12732# m3_n3682_12620# 0.06144f
C1599 m3_n3794_n18180# m3_n3682_n18180# 0.06144f
C1600 m3_n3906_20236# m3_n3906_20348# 0.06144f
C1601 m3_n3794_17996# m3_n3794_17884# 0.06144f
C1602 m3_n3682_n15604# m3_n3682_n15716# 0.06144f
C1603 m3_n3906_1196# m3_n3906_1084# 0.06144f
C1604 m3_n3906_11724# m3_n3906_11836# 0.06144f
C1605 m3_n3794_n19412# m3_n3794_n19300# 0.06144f
C1606 m3_n3906_n4292# m3_n3794_n4292# 0.06144f
C1607 m3_n3906_n7540# m3_n3906_n7652# 0.06144f
C1608 m3_n3794_21244# m3_n3794_21132# 0.06144f
C1609 m3_n3794_n17396# m3_n3682_n17396# 0.06144f
C1610 m3_n3906_20012# m3_n3794_20012# 0.06144f
C1611 m3_n3906_12172# m3_n3906_12284# 0.06144f
C1612 m3_n3682_n7988# m3_n3682_n7876# 0.06144f
C1613 m3_n3794_n7988# m3_n3906_n7988# 0.06144f
C1614 m3_n3794_21468# m3_n3794_21356# 0.06144f
C1615 m3_n3794_n18516# m3_n3682_n18516# 0.06144f
C1616 m3_n3682_300# m3_n3386_n6343# 0.0178f
C1617 m3_n3682_1084# m3_n3682_1196# 0.06144f
C1618 m3_n3906_n15044# m3_n3794_n15044# 0.06144f
C1619 m3_n3682_n148# m3_n3386_n6343# 0.0178f
C1620 m3_n3682_18220# m3_n3794_18220# 0.06144f
C1621 m3_n3906_18108# m3_n3906_18220# 0.06144f
C1622 m3_n3906_12732# m3_n3794_12732# 0.06144f
C1623 m3_n3682_12844# m3_n3682_12732# 0.06144f
C1624 m3_n3906_3772# m3_n3794_3772# 0.06144f
C1625 m3_n3682_n16052# m3_n3682_n15940# 0.06144f
C1626 m3_n3794_n16052# m3_n3906_n16052# 0.06144f
C1627 m3_n3794_n9332# m3_n3794_n9220# 0.06144f
C1628 m3_n3794_n9444# m3_n3794_n9332# 0.06144f
C1629 m3_n3682_n10116# m3_n3682_n10004# 0.06144f
C1630 m3_n3794_n10788# m3_n3794_n10676# 0.06144f
C1631 m3_n3682_n7876# m3_n3794_n7876# 0.06144f
C1632 m3_n3906_n7988# m3_n3906_n7876# 0.06144f
C1633 m3_n3906_n14820# m3_n3794_n14820# 0.06144f
C1634 m3_n3682_n2612# m3_n3682_n2500# 0.06144f
C1635 m3_n3906_15980# m3_n3906_16092# 0.06144f
C1636 m3_n3794_n2612# m3_n3906_n2612# 0.06144f
C1637 m3_n3906_n10228# m3_n3906_n10340# 0.06144f
C1638 m3_n3682_15420# m3_n3682_15532# 0.06144f
C1639 m3_n3682_n3060# m3_n3386_n6343# 0.0178f
C1640 m3_n3906_n18180# m3_n3906_n18068# 0.06144f
C1641 m3_n3794_15420# m3_n3906_15420# 0.06144f
C1642 m3_n3906_14748# m3_n3906_14860# 0.06144f
C1643 m3_n3794_n6196# m3_n3682_n6196# 0.06144f
C1644 m3_n3682_14860# m3_n3794_14860# 0.06144f
C1645 m3_n3794_n12692# m3_n3682_n12692# 0.06144f
C1646 m3_n3386_n6343# m3_n3682_n5972# 0.0178f
C1647 m3_n3682_15196# m3_n3682_15308# 0.06144f
C1648 m3_n3794_15196# m3_n3906_15196# 0.06144f
C1649 m3_n3794_19676# m3_n3794_19788# 0.06144f
C1650 m3_n3794_n12020# m3_n3794_n11908# 0.06144f
C1651 m3_n3794_n15716# m3_n3682_n15716# 0.06144f
C1652 m3_n3906_n15716# m3_n3906_n15828# 0.06144f
C1653 m3_n3682_20908# m3_n3682_21020# 0.06144f
C1654 m3_n3906_20908# m3_n3794_20908# 0.06144f
C1655 m3_n3906_n17396# m3_n3906_n17508# 0.06144f
C1656 m3_n3906_3436# m3_n3794_3436# 0.06144f
C1657 m3_n3682_3548# m3_n3682_3436# 0.06144f
C1658 m3_n3906_6572# m3_n3794_6572# 0.06144f
C1659 m3_n3794_n12916# m3_n3794_n12804# 0.06144f
C1660 m3_n3906_3324# m3_n3794_3324# 0.06144f
C1661 m3_n3794_2540# m3_n3794_2652# 0.06144f
C1662 m3_n3906_n2724# m3_n3794_n2724# 0.06144f
C1663 m3_n3682_12844# m3_n3794_12844# 0.06144f
C1664 m3_n3794_9260# m3_n3682_9260# 0.06144f
C1665 m3_n3906_12732# m3_n3906_12844# 0.06144f
C1666 m3_n3906_9260# m3_n3906_9148# 0.06144f
C1667 m3_n3682_n2052# m3_n3386_n6343# 0.0178f
C1668 m3_n3906_9372# m3_n3794_9372# 0.06144f
C1669 m3_n3794_n4516# m3_n3682_n4516# 0.06144f
C1670 m3_n3682_n7652# m3_n3794_n7652# 0.06144f
C1671 m3_n3682_9484# m3_n3682_9372# 0.06144f
C1672 m3_n3906_n4516# m3_n3906_n4628# 0.06144f
C1673 m3_n3906_n7764# m3_n3906_n7652# 0.06144f
C1674 m3_n3682_n3396# m3_n3682_n3508# 0.06144f
C1675 m3_n3906_n3508# m3_n3794_n3508# 0.06144f
C1676 m3_n3682_10828# m3_n3794_10828# 0.06144f
C1677 m3_n3906_10716# m3_n3906_10828# 0.06144f
C1678 m3_n3682_n14820# m3_n3682_n14708# 0.06144f
C1679 m3_n3794_15196# m3_n3682_15196# 0.06144f
C1680 m3_n3906_9372# m3_n3906_9484# 0.06144f
C1681 m3_n3906_n17060# m3_n3794_n17060# 0.06144f
C1682 m3_n3682_9484# m3_n3794_9484# 0.06144f
C1683 m3_n3794_n19860# m3_n3682_n19860# 0.06144f
C1684 m3_n3906_16652# m3_n3794_16652# 0.06144f
C1685 m3_n3794_n15156# m3_n3794_n15268# 0.06144f
C1686 m3_n3682_n14708# m3_n3682_n14596# 0.06144f
C1687 m3_n3794_n14708# m3_n3906_n14708# 0.06144f
C1688 m3_n3682_3100# m3_n3682_3212# 0.06144f
C1689 m3_n3794_n18852# m3_n3682_n18852# 0.06144f
C1690 m3_n3794_n13588# m3_n3794_n13476# 0.06144f
C1691 m3_n3906_n16836# m3_n3906_n16724# 0.06144f
C1692 m3_n3794_13628# m3_n3794_13740# 0.06144f
C1693 m3_n3906_1420# m3_n3906_1308# 0.06144f
C1694 m3_n3906_n6980# m3_n3906_n7092# 0.06144f
C1695 m3_n3794_n6980# m3_n3682_n6980# 0.06144f
C1696 m3_n3906_n10564# m3_n3794_n10564# 0.06144f
C1697 m3_n3794_10380# m3_n3794_10268# 0.06144f
C1698 m3_n3682_n708# m3_n3386_n6343# 0.0178f
C1699 m3_n3682_n17732# m3_n3682_n17620# 0.06144f
C1700 m3_n3682_n3284# m3_n3386_n6343# 0.0178f
C1701 m3_n3682_9708# m3_n3682_9820# 0.06144f
C1702 m3_n3906_n18404# m3_n3906_n18292# 0.06144f
C1703 m3_n3794_n16052# m3_n3794_n15940# 0.06144f
C1704 m3_n3682_n12244# m3_n3682_n12356# 0.06144f
C1705 m3_n3794_n9780# m3_n3682_n9780# 0.06144f
C1706 m3_n3906_n7092# m3_n3906_n7204# 0.06144f
C1707 m3_n3906_22252# m3_n3794_22252# 0.06144f
C1708 m3_n3794_7692# m3_n3794_7804# 0.06144f
C1709 m3_n3906_11612# m3_n3906_11500# 0.06144f
C1710 m3_n3906_14972# m3_n3906_14860# 0.06144f
C1711 m3_n3682_9036# m3_n3794_9036# 0.06144f
C1712 m3_n3794_n15380# m3_n3906_n15380# 0.06144f
C1713 m3_n3906_8924# m3_n3906_9036# 0.06144f
C1714 m3_n3682_n15380# m3_n3682_n15268# 0.06144f
C1715 m3_n3906_n2276# m3_n3794_n2276# 0.06144f
C1716 m3_n3794_n11348# m3_n3906_n11348# 0.06144f
C1717 m3_n3794_15420# m3_n3794_15532# 0.06144f
C1718 m3_n3682_n11348# m3_n3682_n11236# 0.06144f
C1719 m3_n3794_8924# m3_n3682_8924# 0.06144f
C1720 m3_n3794_10940# m3_n3794_10828# 0.06144f
C1721 m3_n3794_7132# m3_n3682_7132# 0.06144f
C1722 m3_n3794_n17956# m3_n3794_n17844# 0.06144f
C1723 m3_n3794_17436# m3_n3794_17548# 0.06144f
C1724 m3_n3794_6684# m3_n3794_6572# 0.06144f
C1725 m3_n3794_10044# m3_n3794_10156# 0.06144f
C1726 m3_n3794_1868# m3_n3682_1868# 0.06144f
C1727 m3_n3794_22812# m3_n3794_22700# 0.06144f
C1728 m3_n3682_n4740# m3_n3682_n4628# 0.06144f
C1729 m3_n3906_n8212# m3_n3906_n8324# 0.06144f
C1730 m3_n3906_n7764# m3_n3794_n7764# 0.06144f
C1731 m3_n3794_18332# m3_n3794_18220# 0.06144f
C1732 m3_n3906_n8436# m3_n3906_n8548# 0.06144f
C1733 m3_n3682_n7652# m3_n3682_n7764# 0.06144f
C1734 m3_n3794_7692# m3_n3794_7580# 0.06144f
C1735 m3_n3794_2988# m3_n3682_2988# 0.06144f
C1736 m3_n3794_n10452# m3_n3794_n10340# 0.06144f
C1737 m3_n3682_n13700# m3_n3682_n13588# 0.06144f
C1738 m3_n3906_n5636# m3_n3794_n5636# 0.06144f
C1739 m3_n3906_n7316# m3_n3906_n7428# 0.06144f
C1740 m3_n3906_n260# m3_n3794_n260# 0.06144f
C1741 m3_n3906_n17844# m3_n3794_n17844# 0.06144f
C1742 m3_n3794_n9108# m3_n3794_n8996# 0.06144f
C1743 m3_n3682_n12692# m3_n3682_n12804# 0.06144f
C1744 m3_n3906_n11012# m3_n3906_n11124# 0.06144f
C1745 m3_n3794_n484# m3_n3794_n372# 0.06144f
C1746 m3_n3794_n260# m3_n3682_n260# 0.06144f
C1747 m3_n3794_n11012# m3_n3682_n11012# 0.06144f
C1748 m3_n3906_n260# m3_n3906_n372# 0.06144f
C1749 m3_n3682_5340# m3_n3386_n6343# 0.0178f
C1750 m3_n3794_n6308# m3_n3794_n6420# 0.06144f
C1751 m3_n3906_20012# m3_n3906_20124# 0.06144f
C1752 m3_n3682_n17508# m3_n3682_n17620# 0.06144f
C1753 m3_n3906_13964# m3_n3794_13964# 0.06144f
C1754 m3_n3906_19452# m3_n3906_19340# 0.06144f
C1755 m3_n3794_11388# m3_n3682_11388# 0.06144f
C1756 m3_n3682_n7204# m3_n3794_n7204# 0.06144f
C1757 m3_n3906_n7316# m3_n3906_n7204# 0.06144f
C1758 m3_n3794_n15828# m3_n3682_n15828# 0.06144f
C1759 m3_n3682_n1380# m3_n3386_n6343# 0.0178f
C1760 m3_n3682_18220# m3_n3682_18332# 0.06144f
C1761 m3_n3682_21804# m3_n3794_21804# 0.06144f
C1762 m3_n3906_21692# m3_n3906_21804# 0.06144f
C1763 m3_n3682_3660# m3_n3386_n6343# 0.0178f
C1764 m3_n3906_7692# m3_n3906_7804# 0.06144f
C1765 m3_n3682_n19412# m3_n3682_n19300# 0.06144f
C1766 m3_n3906_n1492# m3_n3906_n1604# 0.06144f
C1767 m3_n3794_15420# m3_n3794_15308# 0.06144f
C1768 m3_n3682_n4180# m3_n3386_n6343# 0.0178f
C1769 x13/X VDPWR 0.07456f
C1770 m3_n3682_12060# m3_n3682_11948# 0.06144f
C1771 m3_n3794_n11460# m3_n3794_n11572# 0.06144f
C1772 m3_n3906_n4852# m3_n3906_n4740# 0.06144f
C1773 m3_n3682_n4740# m3_n3794_n4740# 0.06144f
C1774 m3_n3906_11724# m3_n3794_11724# 0.06144f
C1775 m3_n3682_7020# m3_n3682_6908# 0.06144f
C1776 m3_n3682_n6756# m3_n3682_n6644# 0.06144f
C1777 m3_n3906_6908# m3_n3794_6908# 0.06144f
C1778 m3_n3906_n19748# m3_n3906_n19636# 0.06144f
C1779 m3_n3906_14636# m3_n3794_14636# 0.06144f
C1780 m3_n3682_4220# m3_n3794_4220# 0.06144f
C1781 m3_n3794_4892# m3_n3794_5004# 0.06144f
C1782 m3_n3906_4108# m3_n3906_4220# 0.06144f
C1783 m3_n3906_412# m3_n3906_524# 0.06144f
C1784 m3_n3682_n9892# m3_n3682_n9780# 0.06144f
C1785 m3_n3682_972# m3_n3386_n6343# 0.0178f
C1786 m3_n3386_n6343# m3_n3682_2876# 0.0178f
C1787 m3_n3794_9148# m3_n3682_9148# 0.06144f
C1788 m3_n3682_n1380# m3_n3794_n1380# 0.06144f
C1789 m3_n3906_n5860# m3_n3906_n5748# 0.06144f
C1790 m3_n3906_n1492# m3_n3906_n1380# 0.06144f
C1791 m3_n3906_n11348# m3_n3906_n11236# 0.06144f
C1792 m3_n3682_n11236# m3_n3794_n11236# 0.06144f
C1793 x13/X x9/Y 0.02127f
C1794 m3_n3794_20908# m3_n3794_21020# 0.06144f
C1795 m3_n3794_n5748# m3_n3906_n5748# 0.06144f
C1796 m3_n3794_n19524# m3_n3794_n19412# 0.06144f
C1797 m3_n3682_n5748# m3_n3682_n5636# 0.06144f
C1798 m3_n3682_1084# m3_n3386_n6343# 0.0178f
C1799 m3_n3794_n14932# m3_n3906_n14932# 0.06144f
C1800 m3_n3794_6684# m3_n3682_6684# 0.06144f
C1801 m3_n3682_n14932# m3_n3682_n14820# 0.06144f
C1802 m3_n3906_n3844# m3_n3906_n3732# 0.06144f
C1803 m3_n3794_n7092# m3_n3794_n6980# 0.06144f
C1804 m3_n3794_n12468# m3_n3682_n12468# 0.06144f
C1805 m3_n3906_5564# m3_n3906_5676# 0.06144f
C1806 m3_n3794_n10564# m3_n3794_n10676# 0.06144f
C1807 m3_n3906_4780# m3_n3794_4780# 0.06144f
C1808 m3_n3682_4892# m3_n3682_4780# 0.06144f
C1809 m3_n3794_13404# m3_n3794_13516# 0.06144f
C1810 m3_n3794_20124# m3_n3794_20236# 0.06144f
C1811 m3_n3794_n11348# m3_n3794_n11460# 0.06144f
C1812 m3_n3906_2428# m3_n3906_2316# 0.06144f
C1813 m3_n3794_11052# m3_n3682_11052# 0.06144f
C1814 m3_n3906_11052# m3_n3906_10940# 0.06144f
C1815 m3_n3794_2428# m3_n3682_2428# 0.06144f
C1816 m3_n3794_15868# m3_n3794_15756# 0.06144f
C1817 m3_n3794_n7092# m3_n3794_n7204# 0.06144f
C1818 m3_n3794_9932# m3_n3682_9932# 0.06144f
C1819 m3_n3682_14524# m3_n3682_14412# 0.06144f
C1820 m3_n3906_n9892# m3_n3794_n9892# 0.06144f
C1821 m3_n3794_n3508# m3_n3682_n3508# 0.06144f
C1822 m3_n3906_9932# m3_n3906_9820# 0.06144f
C1823 m3_n3682_22140# m3_n3682_22252# 0.06144f
C1824 m3_n3794_22140# m3_n3906_22140# 0.06144f
C1825 m3_n3794_5676# m3_n3682_5676# 0.06144f
C1826 m3_n3906_n2388# m3_n3906_n2276# 0.06144f
C1827 m3_n3682_n2276# m3_n3794_n2276# 0.06144f
C1828 m3_n3794_8924# m3_n3794_8812# 0.06144f
C1829 m3_n3386_n6343# m3_n3682_n5076# 0.0178f
C1830 m3_n3906_n10564# m3_n3906_n10452# 0.06144f
C1831 m3_n3794_n17060# m3_n3682_n17060# 0.06144f
C1832 m3_n3682_n11796# m3_n3682_n11684# 0.06144f
C1833 m3_n3794_10716# m3_n3794_10828# 0.06144f
C1834 m3_n3794_n11796# m3_n3906_n11796# 0.06144f
C1835 m3_n3682_17212# m3_n3682_17100# 0.06144f
C1836 m3_n3682_19340# m3_n3794_19340# 0.06144f
C1837 m3_n3906_19228# m3_n3906_19340# 0.06144f
C1838 m3_n3682_2316# m3_n3682_2204# 0.06144f
C1839 m3_n3682_22924# m3_n3794_22924# 0.06144f
C1840 m3_n3906_22812# m3_n3906_22924# 0.06144f
C1841 m3_n3906_1644# m3_n3906_1756# 0.06144f
C1842 m3_n3794_7132# m3_n3794_7020# 0.06144f
C1843 m3_n3682_1756# m3_n3794_1756# 0.06144f
C1844 m3_n3906_11276# m3_n3906_11388# 0.06144f
C1845 m3_n3682_n10452# m3_n3682_n10564# 0.06144f
C1846 m3_n3794_16428# m3_n3794_16316# 0.06144f
C1847 m3_n3794_n9556# m3_n3794_n9444# 0.06144f
C1848 m3_n3682_8812# m3_n3682_8700# 0.06144f
C1849 m3_n3682_1084# m3_n3682_972# 0.06144f
C1850 m3_n3906_972# m3_n3794_972# 0.06144f
C1851 m3_n3906_8700# m3_n3794_8700# 0.06144f
C1852 m3_n3682_4892# m3_n3794_4892# 0.06144f
C1853 m3_n3906_4780# m3_n3906_4892# 0.06144f
C1854 m3_n3794_10604# m3_n3794_10492# 0.06144f
C1855 m3_n3794_21692# m3_n3794_21804# 0.06144f
C1856 m3_n3906_13292# m3_n3906_13180# 0.06144f
C1857 m3_n3794_13292# m3_n3682_13292# 0.06144f
C1858 m3_n3794_11500# m3_n3794_11612# 0.06144f
C1859 m3_n3794_9372# m3_n3682_9372# 0.06144f
C1860 m3_n3906_12620# m3_n3794_12620# 0.06144f
C1861 m3_n3906_22476# m3_n3794_22476# 0.06144f
C1862 m3_n3794_3548# m3_n3794_3436# 0.06144f
C1863 m3_n3794_18332# m3_n3682_18332# 0.06144f
C1864 m3_n3682_13516# m3_n3794_13516# 0.06144f
C1865 m3_n3906_n17732# m3_n3906_n17844# 0.06144f
C1866 m3_n3906_n9780# m3_n3906_n9892# 0.06144f
C1867 m3_n3906_13404# m3_n3906_13516# 0.06144f
C1868 m3_n3906_17100# m3_n3794_17100# 0.06144f
C1869 m3_n3794_9372# m3_n3794_9484# 0.06144f
C1870 m3_n3906_n3172# m3_n3794_n3172# 0.06144f
C1871 m3_n3906_n14484# m3_n3794_n14484# 0.06144f
C1872 m3_n3906_3324# m3_n3906_3436# 0.06144f
C1873 m3_n3682_n17956# m3_n3682_n17844# 0.06144f
C1874 m3_n3682_n14372# m3_n3682_n14484# 0.06144f
C1875 m3_n3906_n8772# m3_n3906_n8660# 0.06144f
C1876 m3_n3794_15644# m3_n3682_15644# 0.06144f
C1877 m3_n3794_n14036# m3_n3682_n14036# 0.06144f
C1878 m3_n3906_5116# m3_n3794_5116# 0.06144f
C1879 m3_n3386_n6343# m3_n3682_n5188# 0.0178f
C1880 m3_n3682_n14148# m3_n3794_n14148# 0.06144f
C1881 m3_n3794_n3732# m3_n3682_n3732# 0.06144f
C1882 m3_n3682_19564# m3_n3682_19452# 0.06144f
C1883 m3_n3906_n14260# m3_n3906_n14148# 0.06144f
C1884 m3_n3794_19004# m3_n3682_19004# 0.06144f
C1885 m3_n3906_19452# m3_n3794_19452# 0.06144f
C1886 m3_n3906_9484# m3_n3794_9484# 0.06144f
C1887 m3_n3906_n18516# m3_n3906_n18404# 0.06144f
C1888 m3_n3682_n13476# m3_n3682_n13364# 0.06144f
C1889 m3_n3794_n4404# m3_n3682_n4404# 0.06144f
C1890 m3_n3682_13852# m3_n3682_13740# 0.06144f
C1891 m3_n3794_8028# m3_n3682_8028# 0.06144f
C1892 m3_n3906_1196# m3_n3906_1308# 0.06144f
C1893 m3_n3682_1308# m3_n3794_1308# 0.06144f
C1894 m3_n3682_n1716# m3_n3386_n6343# 0.0178f
C1895 m3_n3794_n14484# m3_n3794_n14596# 0.06144f
C1896 m3_n3794_8028# m3_n3794_7916# 0.06144f
C1897 m3_n3906_n17172# m3_n3794_n17172# 0.06144f
C1898 m3_n3906_n13028# m3_n3794_n13028# 0.06144f
C1899 m3_n3906_7916# m3_n3794_7916# 0.06144f
C1900 m3_n3794_n14708# m3_n3794_n14820# 0.06144f
C1901 m3_n3906_n19076# m3_n3794_n19076# 0.06144f
C1902 m3_n3386_n6343# m3_n3682_4108# 0.0178f
C1903 m3_n3794_8700# m3_n3794_8588# 0.06144f
C1904 m3_n3794_20572# m3_n3794_20460# 0.06144f
C1905 m3_n3794_n2164# m3_n3682_n2164# 0.06144f
C1906 m3_n3682_5788# m3_n3682_5900# 0.06144f
C1907 m3_n3906_17772# m3_n3906_17660# 0.06144f
C1908 m3_n3794_17772# m3_n3682_17772# 0.06144f
C1909 m3_n3794_14972# m3_n3682_14972# 0.06144f
C1910 x13/X x15/a_109_47# 0
C1911 m3_n3794_n8884# m3_n3794_n8996# 0.06144f
C1912 m3_n3794_n10676# m3_n3682_n10676# 0.06144f
C1913 m3_n3794_n8548# m3_n3794_n8436# 0.06144f
C1914 m3_n3794_21020# m3_n3682_21020# 0.06144f
C1915 m3_n3794_n15044# m3_n3682_n15044# 0.06144f
C1916 m3_n3906_n15044# m3_n3906_n15156# 0.06144f
C1917 m3_n3794_n5636# m3_n3682_n5636# 0.06144f
C1918 m3_n3906_n5636# m3_n3906_n5748# 0.06144f
C1919 m3_n3906_8812# m3_n3794_8812# 0.06144f
C1920 m3_n3794_3996# m3_n3794_4108# 0.06144f
C1921 m3_n3794_n1828# m3_n3794_n1940# 0.06144f
C1922 m3_n3682_5564# m3_n3794_5564# 0.06144f
C1923 m3_n3906_5452# m3_n3906_5564# 0.06144f
C1924 m3_n3794_22588# m3_n3682_22588# 0.06144f
C1925 m3_n3682_4668# m3_n3682_4780# 0.06144f
C1926 m3_n3906_n2500# m3_n3906_n2388# 0.06144f
C1927 m3_n3682_n19524# m3_n3682_n19412# 0.06144f
C1928 m3_n3794_22588# m3_n3794_22700# 0.06144f
C1929 x14/X x9/A 0.00676f
C1930 m3_n3906_n4292# m3_n3906_n4180# 0.06144f
C1931 m3_n3906_n14372# m3_n3906_n14484# 0.06144f
C1932 m3_n3906_n2500# m3_n3794_n2500# 0.06144f
C1933 m3_n3794_n14372# m3_n3682_n14372# 0.06144f
C1934 m3_n3794_8028# m3_n3794_8140# 0.06144f
C1935 m3_n3906_22700# m3_n3794_22700# 0.06144f
C1936 m3_n3794_21244# m3_n3794_21356# 0.06144f
C1937 m3_n3906_n19860# m3_n3906_n19748# 0.06144f
C1938 m3_n3794_19228# m3_n3906_19228# 0.06144f
C1939 m3_n3682_19228# m3_n3682_19340# 0.06144f
C1940 m3_n3794_n15156# m3_n3682_n15156# 0.06144f
C1941 m3_n3906_n5972# m3_n3906_n5860# 0.06144f
C1942 m3_n3906_n18964# m3_n3794_n18964# 0.06144f
C1943 m3_n3682_n5860# m3_n3794_n5860# 0.06144f
C1944 m3_n3906_7020# m3_n3794_7020# 0.06144f
C1945 m3_n3906_n3620# m3_n3794_n3620# 0.06144f
C1946 m3_n3682_n5748# m3_n3682_n5860# 0.06144f
C1947 m3_n3682_21356# m3_n3682_21468# 0.06144f
C1948 m3_n3906_10380# m3_n3794_10380# 0.06144f
C1949 m3_n3794_16988# m3_n3682_16988# 0.06144f
C1950 m3_n3682_9484# m3_n3682_9596# 0.06144f
C1951 m3_n3906_20908# m3_n3906_21020# 0.06144f
C1952 m3_n3794_2540# m3_n3682_2540# 0.06144f
C1953 m3_n3906_13964# m3_n3906_14076# 0.06144f
C1954 m3_n3682_19340# m3_n3682_19452# 0.06144f
C1955 m3_n3794_n3956# m3_n3682_n3956# 0.06144f
C1956 m3_n3906_5004# m3_n3906_5116# 0.06144f
C1957 m3_n3682_5116# m3_n3794_5116# 0.06144f
C1958 x9/A x14/a_109_47# 0.02129f
C1959 m3_n3794_n19636# m3_n3794_n19524# 0.06144f
C1960 m3_n3906_n16388# m3_n3794_n16388# 0.06144f
C1961 m3_n3794_1868# m3_n3906_1868# 0.06144f
C1962 m3_n3682_1868# m3_n3682_1980# 0.06144f
C1963 m3_n3906_9932# m3_n3794_9932# 0.06144f
C1964 m3_n3794_14076# m3_n3794_14188# 0.06144f
C1965 m3_n3794_n5524# m3_n3682_n5524# 0.06144f
C1966 m3_n3682_n8548# m3_n3682_n8436# 0.06144f
C1967 m3_n3906_n12132# m3_n3794_n12132# 0.06144f
C1968 m3_n3682_n5188# m3_n3682_n5076# 0.06144f
C1969 m3_n3794_n18740# m3_n3682_n18740# 0.06144f
C1970 m3_n3794_n1492# m3_n3682_n1492# 0.06144f
C1971 m3_n3794_n8772# m3_n3682_n8772# 0.06144f
C1972 m3_n3794_n17172# m3_n3794_n17060# 0.06144f
C1973 m3_n3794_n2724# m3_n3794_n2612# 0.06144f
C1974 m3_n3794_n4516# m3_n3794_n4628# 0.06144f
C1975 m3_n3906_n8772# m3_n3906_n8884# 0.06144f
C1976 m3_n3682_n1156# m3_n3386_n6343# 0.0178f
C1977 m3_n3906_15868# m3_n3906_15756# 0.06144f
C1978 m3_n3906_n3172# m3_n3906_n3060# 0.06144f
C1979 m3_n3906_8140# m3_n3794_8140# 0.06144f
C1980 m3_n3906_n36# m3_n3794_n36# 0.06144f
C1981 m3_n3906_n484# m3_n3794_n484# 0.06144f
C1982 m3_n3682_13068# m3_n3682_13180# 0.06144f
C1983 m3_n3794_7804# m3_n3794_7916# 0.06144f
C1984 m3_n3794_9260# m3_n3794_9148# 0.06144f
C1985 m3_n3906_1532# m3_n3906_1420# 0.06144f
C1986 m3_n3906_2204# m3_n3906_2316# 0.06144f
C1987 m3_n3794_1532# m3_n3682_1532# 0.06144f
C1988 m3_n3794_21804# m3_n3794_21916# 0.06144f
C1989 m3_n3794_n14932# m3_n3794_n15044# 0.06144f
C1990 m3_n3682_n708# m3_n3682_n820# 0.06144f
C1991 m3_n3906_n820# m3_n3794_n820# 0.06144f
C1992 m3_n3682_2988# m3_n3682_3100# 0.06144f
C1993 m3_n3794_2988# m3_n3906_2988# 0.06144f
C1994 m3_n3682_n11236# m3_n3682_n11124# 0.06144f
C1995 m3_n3906_n15492# m3_n3906_n15380# 0.06144f
C1996 m3_n3794_22476# m3_n3794_22364# 0.06144f
C1997 m3_n3794_11948# m3_n3794_11836# 0.06144f
C1998 m3_n3906_10940# m3_n3906_10828# 0.06144f
C1999 m3_n3794_5676# m3_n3794_5788# 0.06144f
C2000 m3_n3794_n14932# m3_n3794_n14820# 0.06144f
C2001 m3_n3906_n1268# m3_n3906_n1380# 0.06144f
C2002 m3_n3794_18668# m3_n3794_18780# 0.06144f
C2003 m3_n3906_16316# m3_n3906_16204# 0.06144f
C2004 m3_n3794_n12244# m3_n3906_n12244# 0.06144f
C2005 m3_n3682_n12244# m3_n3682_n12132# 0.06144f
C2006 m3_n3906_17324# m3_n3906_17436# 0.06144f
C2007 m3_n3906_n18292# m3_n3906_n18180# 0.06144f
C2008 m3_n3682_11500# m3_n3682_11612# 0.06144f
C2009 m3_n3682_n820# m3_n3386_n6343# 0.0178f
C2010 m3_n3794_18892# m3_n3794_18780# 0.06144f
C2011 m3_n3794_4556# m3_n3794_4668# 0.06144f
C2012 x9/Y m3_n3386_n6343# 25.36021f
C2013 m3_n3794_n2948# m3_n3794_n2836# 0.06144f
C2014 m3_n3682_1420# m3_n3386_n6343# 0.0178f
C2015 m3_n3794_n18180# m3_n3794_n18068# 0.06144f
C2016 m3_n3794_n12356# m3_n3794_n12468# 0.06144f
C2017 m3_n3906_n16276# m3_n3906_n16388# 0.06144f
C2018 m3_n3386_n6343# m3_n3682_3436# 0.0178f
C2019 m3_n3906_17772# m3_n3794_17772# 0.06144f
C2020 m3_n3682_8028# m3_n3682_7916# 0.06144f
C2021 m3_n3794_n17396# m3_n3794_n17508# 0.06144f
C2022 m3_n3794_n19076# m3_n3682_n19076# 0.06144f
C2023 m3_n3794_10156# m3_n3794_10268# 0.06144f
C2024 m3_n3906_2092# m3_n3794_2092# 0.06144f
C2025 m3_n3682_2204# m3_n3682_2092# 0.06144f
C2026 m3_n3906_7804# m3_n3906_7916# 0.06144f
C2027 m3_n3682_7916# m3_n3794_7916# 0.06144f
C2028 m3_n3794_1420# m3_n3794_1308# 0.06144f
C2029 m3_n3682_10044# m3_n3682_10156# 0.06144f
C2030 m3_n3794_10044# m3_n3906_10044# 0.06144f
C2031 m3_n3794_18668# m3_n3794_18556# 0.06144f
C2032 m3_n3682_n6868# m3_n3682_n6980# 0.06144f
C2033 m3_n3794_n5300# m3_n3682_n5300# 0.06144f
C2034 m3_n3906_11052# m3_n3794_11052# 0.06144f
C2035 m3_n3794_7356# m3_n3682_7356# 0.06144f
C2036 m3_n3906_n596# m3_n3906_n708# 0.06144f
C2037 m3_n3794_2316# m3_n3682_2316# 0.06144f
C2038 m3_n3794_20572# m3_n3794_20684# 0.06144f
C2039 m3_n3794_12060# m3_n3682_12060# 0.06144f
C2040 m3_n3794_n7316# m3_n3682_n7316# 0.06144f
C2041 m3_n3906_15084# m3_n3906_15196# 0.06144f
C2042 m3_n3906_n18628# m3_n3906_n18516# 0.06144f
C2043 m3_n3794_14412# m3_n3794_14300# 0.06144f
C2044 m3_n3794_13852# m3_n3794_13740# 0.06144f
C2045 m3_n3906_17548# m3_n3794_17548# 0.06144f
C2046 m3_n3794_16764# m3_n3682_16764# 0.06144f
C2047 m3_n3906_13628# m3_n3906_13516# 0.06144f
C2048 m3_n3682_n4964# m3_n3386_n6343# 0.0178f
C2049 m3_n3682_20236# m3_n3682_20348# 0.06144f
C2050 m3_n3906_n7540# m3_n3906_n7428# 0.06144f
C2051 m3_n3906_76# m3_n3906_n36# 0.06144f
C2052 m3_n3682_n7428# m3_n3794_n7428# 0.06144f
C2053 m3_n3794_n15604# m3_n3682_n15604# 0.06144f
C2054 m3_n3906_n5636# m3_n3906_n5524# 0.06144f
C2055 m3_n3906_n10004# m3_n3794_n10004# 0.06144f
C2056 m3_n3682_n9892# m3_n3682_n10004# 0.06144f
C2057 m3_n3794_5900# m3_n3794_6012# 0.06144f
C2058 x8/A m3_n3386_n6343# 25.1643f
C2059 m3_n3906_17884# m3_n3906_17772# 0.06144f
C2060 m3_n3794_4556# m3_n3794_4444# 0.06144f
C2061 m3_n3794_n18404# m3_n3794_n18292# 0.06144f
C2062 m3_n3794_15196# m3_n3794_15084# 0.06144f
C2063 x16/a_109_47# VDPWR 0.03514f
C2064 m3_n3794_n13924# m3_n3794_n14036# 0.06144f
C2065 m3_n3682_n16388# m3_n3794_n16388# 0.06144f
C2066 m3_n3906_n16500# m3_n3906_n16388# 0.06144f
C2067 m3_n3794_12396# m3_n3794_12508# 0.06144f
C2068 m3_n3682_n3396# m3_n3682_n3284# 0.06144f
C2069 m3_n3682_n16836# m3_n3682_n16948# 0.06144f
C2070 m3_n3906_n16948# m3_n3794_n16948# 0.06144f
C2071 m3_n3682_17100# m3_n3682_16988# 0.06144f
C2072 m3_n3682_860# m3_n3386_n6343# 0.0178f
C2073 m3_n3906_16988# m3_n3794_16988# 0.06144f
C2074 m3_n3794_21020# m3_n3906_21020# 0.06144f
C2075 m3_n3794_860# m3_n3794_972# 0.06144f
C2076 m3_n3682_21020# m3_n3682_21132# 0.06144f
C2077 m3_n3794_14748# m3_n3794_14636# 0.06144f
C2078 m3_n3906_5340# m3_n3794_5340# 0.06144f
C2079 m3_n3794_7804# m3_n3682_7804# 0.06144f
C2080 m3_n3906_n7428# m3_n3794_n7428# 0.06144f
C2081 m3_n3682_n13140# m3_n3682_n13028# 0.06144f
C2082 m3_n3794_n13140# m3_n3906_n13140# 0.06144f
C2083 m3_n3906_n6980# m3_n3794_n6980# 0.06144f
C2084 m3_n3794_12620# m3_n3794_12732# 0.06144f
C2085 m3_n3906_524# m3_n3794_524# 0.06144f
C2086 m3_n3682_636# m3_n3682_524# 0.06144f
C2087 m3_n3794_8476# m3_n3682_8476# 0.06144f
C2088 m3_n3682_n19972# VSUBS 0.04811f
C2089 m3_n3794_n19972# VSUBS 0.02819f
C2090 m3_n3906_n19972# VSUBS 0.04811f
C2091 m3_n3682_n19860# VSUBS 0.02819f
C2092 m3_n3794_n19860# VSUBS 0.00826f
C2093 m3_n3906_n19860# VSUBS 0.02819f
C2094 m3_n3682_n19748# VSUBS 0.02819f
C2095 m3_n3794_n19748# VSUBS 0.00826f
C2096 m3_n3906_n19748# VSUBS 0.02819f
C2097 m3_n3682_n19636# VSUBS 0.02819f
C2098 m3_n3794_n19636# VSUBS 0.00826f
C2099 m3_n3906_n19636# VSUBS 0.02819f
C2100 m3_n3682_n19524# VSUBS 0.02819f
C2101 m3_n3794_n19524# VSUBS 0.00826f
C2102 m3_n3906_n19524# VSUBS 0.02819f
C2103 m3_n3682_n19412# VSUBS 0.02819f
C2104 m3_n3794_n19412# VSUBS 0.00826f
C2105 m3_n3906_n19412# VSUBS 0.02819f
C2106 m3_n3682_n19300# VSUBS 0.02819f
C2107 m3_n3794_n19300# VSUBS 0.00826f
C2108 m3_n3906_n19300# VSUBS 0.02819f
C2109 m3_n3682_n19188# VSUBS 0.02819f
C2110 m3_n3794_n19188# VSUBS 0.00826f
C2111 m3_n3906_n19188# VSUBS 0.02819f
C2112 m3_n3682_n19076# VSUBS 0.02819f
C2113 m3_n3794_n19076# VSUBS 0.00826f
C2114 m3_n3906_n19076# VSUBS 0.02819f
C2115 m3_n3682_n18964# VSUBS 0.02819f
C2116 m3_n3794_n18964# VSUBS 0.00826f
C2117 m3_n3906_n18964# VSUBS 0.02819f
C2118 m3_n3682_n18852# VSUBS 0.02819f
C2119 m3_n3794_n18852# VSUBS 0.00826f
C2120 m3_n3906_n18852# VSUBS 0.02819f
C2121 m3_n3682_n18740# VSUBS 0.02819f
C2122 m3_n3794_n18740# VSUBS 0.00826f
C2123 m3_n3906_n18740# VSUBS 0.02819f
C2124 m3_n3682_n18628# VSUBS 0.02819f
C2125 m3_n3794_n18628# VSUBS 0.00826f
C2126 m3_n3906_n18628# VSUBS 0.02819f
C2127 m3_n3682_n18516# VSUBS 0.02819f
C2128 m3_n3794_n18516# VSUBS 0.00826f
C2129 m3_n3906_n18516# VSUBS 0.02819f
C2130 m3_n3682_n18404# VSUBS 0.02819f
C2131 m3_n3794_n18404# VSUBS 0.00826f
C2132 m3_n3906_n18404# VSUBS 0.02819f
C2133 m3_n3682_n18292# VSUBS 0.02819f
C2134 m3_n3794_n18292# VSUBS 0.00826f
C2135 m3_n3906_n18292# VSUBS 0.02819f
C2136 m3_n3682_n18180# VSUBS 0.02819f
C2137 m3_n3794_n18180# VSUBS 0.00826f
C2138 m3_n3906_n18180# VSUBS 0.02819f
C2139 m3_n3682_n18068# VSUBS 0.02819f
C2140 m3_n3794_n18068# VSUBS 0.00826f
C2141 m3_n3906_n18068# VSUBS 0.02819f
C2142 m3_n3682_n17956# VSUBS 0.02819f
C2143 m3_n3794_n17956# VSUBS 0.00826f
C2144 m3_n3906_n17956# VSUBS 0.02819f
C2145 m3_n3682_n17844# VSUBS 0.02819f
C2146 m3_n3794_n17844# VSUBS 0.00826f
C2147 m3_n3906_n17844# VSUBS 0.02819f
C2148 m3_n3682_n17732# VSUBS 0.02819f
C2149 m3_n3794_n17732# VSUBS 0.00826f
C2150 m3_n3906_n17732# VSUBS 0.02819f
C2151 m3_n3682_n17620# VSUBS 0.02819f
C2152 m3_n3794_n17620# VSUBS 0.00826f
C2153 m3_n3906_n17620# VSUBS 0.02819f
C2154 m3_n3682_n17508# VSUBS 0.02819f
C2155 m3_n3794_n17508# VSUBS 0.00826f
C2156 m3_n3906_n17508# VSUBS 0.02819f
C2157 m3_n3682_n17396# VSUBS 0.02819f
C2158 m3_n3794_n17396# VSUBS 0.00826f
C2159 m3_n3906_n17396# VSUBS 0.02819f
C2160 m3_n3682_n17284# VSUBS 0.02819f
C2161 m3_n3794_n17284# VSUBS 0.00826f
C2162 m3_n3906_n17284# VSUBS 0.02819f
C2163 m3_n3682_n17172# VSUBS 0.02819f
C2164 m3_n3794_n17172# VSUBS 0.00826f
C2165 m3_n3906_n17172# VSUBS 0.02819f
C2166 m3_n3682_n17060# VSUBS 0.02819f
C2167 m3_n3794_n17060# VSUBS 0.00826f
C2168 m3_n3906_n17060# VSUBS 0.02819f
C2169 m3_n3682_n16948# VSUBS 0.02819f
C2170 m3_n3794_n16948# VSUBS 0.00826f
C2171 m3_n3906_n16948# VSUBS 0.02819f
C2172 m3_n3682_n16836# VSUBS 0.02819f
C2173 m3_n3794_n16836# VSUBS 0.00826f
C2174 m3_n3906_n16836# VSUBS 0.02819f
C2175 m3_n3682_n16724# VSUBS 0.02819f
C2176 m3_n3794_n16724# VSUBS 0.00826f
C2177 m3_n3906_n16724# VSUBS 0.02819f
C2178 m3_n3682_n16612# VSUBS 0.02819f
C2179 m3_n3794_n16612# VSUBS 0.00826f
C2180 m3_n3906_n16612# VSUBS 0.02819f
C2181 m3_n3682_n16500# VSUBS 0.02819f
C2182 m3_n3794_n16500# VSUBS 0.00826f
C2183 m3_n3906_n16500# VSUBS 0.02819f
C2184 m3_n3682_n16388# VSUBS 0.02819f
C2185 m3_n3794_n16388# VSUBS 0.00826f
C2186 m3_n3906_n16388# VSUBS 0.02819f
C2187 m3_n3682_n16276# VSUBS 0.02819f
C2188 m3_n3794_n16276# VSUBS 0.00826f
C2189 m3_n3906_n16276# VSUBS 0.02819f
C2190 m3_n3682_n16164# VSUBS 0.02819f
C2191 m3_n3794_n16164# VSUBS 0.00826f
C2192 m3_n3906_n16164# VSUBS 0.02819f
C2193 m3_n3682_n16052# VSUBS 0.02819f
C2194 m3_n3794_n16052# VSUBS 0.00826f
C2195 m3_n3906_n16052# VSUBS 0.02819f
C2196 m3_n3682_n15940# VSUBS 0.02819f
C2197 m3_n3794_n15940# VSUBS 0.00826f
C2198 m3_n3906_n15940# VSUBS 0.02819f
C2199 m3_n3682_n15828# VSUBS 0.02819f
C2200 m3_n3794_n15828# VSUBS 0.00826f
C2201 m3_n3906_n15828# VSUBS 0.02819f
C2202 m3_n3682_n15716# VSUBS 0.02819f
C2203 m3_n3794_n15716# VSUBS 0.00826f
C2204 m3_n3906_n15716# VSUBS 0.02819f
C2205 m3_n3682_n15604# VSUBS 0.02819f
C2206 m3_n3794_n15604# VSUBS 0.00826f
C2207 m3_n3906_n15604# VSUBS 0.02819f
C2208 m3_n3682_n15492# VSUBS 0.02819f
C2209 m3_n3794_n15492# VSUBS 0.00826f
C2210 m3_n3906_n15492# VSUBS 0.02819f
C2211 m3_n3682_n15380# VSUBS 0.02819f
C2212 m3_n3794_n15380# VSUBS 0.00826f
C2213 m3_n3906_n15380# VSUBS 0.02819f
C2214 m3_n3682_n15268# VSUBS 0.02819f
C2215 m3_n3794_n15268# VSUBS 0.00826f
C2216 m3_n3906_n15268# VSUBS 0.02819f
C2217 m3_n3682_n15156# VSUBS 0.02819f
C2218 m3_n3794_n15156# VSUBS 0.00826f
C2219 m3_n3906_n15156# VSUBS 0.02819f
C2220 m3_n3682_n15044# VSUBS 0.02819f
C2221 m3_n3794_n15044# VSUBS 0.00826f
C2222 m3_n3906_n15044# VSUBS 0.02819f
C2223 m3_n3682_n14932# VSUBS 0.02819f
C2224 m3_n3794_n14932# VSUBS 0.00826f
C2225 m3_n3906_n14932# VSUBS 0.02819f
C2226 m3_n3682_n14820# VSUBS 0.02819f
C2227 m3_n3794_n14820# VSUBS 0.00826f
C2228 m3_n3906_n14820# VSUBS 0.02819f
C2229 m3_n3682_n14708# VSUBS 0.02819f
C2230 m3_n3794_n14708# VSUBS 0.00826f
C2231 m3_n3906_n14708# VSUBS 0.02819f
C2232 m3_n3682_n14596# VSUBS 0.02819f
C2233 m3_n3794_n14596# VSUBS 0.00826f
C2234 m3_n3906_n14596# VSUBS 0.02819f
C2235 m3_n3682_n14484# VSUBS 0.02819f
C2236 m3_n3794_n14484# VSUBS 0.00826f
C2237 m3_n3906_n14484# VSUBS 0.02819f
C2238 m3_n3682_n14372# VSUBS 0.02819f
C2239 m3_n3794_n14372# VSUBS 0.00826f
C2240 m3_n3906_n14372# VSUBS 0.02819f
C2241 m3_n3682_n14260# VSUBS 0.02819f
C2242 m3_n3794_n14260# VSUBS 0.00826f
C2243 m3_n3906_n14260# VSUBS 0.02819f
C2244 m3_n3682_n14148# VSUBS 0.02819f
C2245 m3_n3794_n14148# VSUBS 0.00826f
C2246 m3_n3906_n14148# VSUBS 0.02819f
C2247 m3_n3682_n14036# VSUBS 0.02819f
C2248 m3_n3794_n14036# VSUBS 0.00826f
C2249 m3_n3906_n14036# VSUBS 0.02819f
C2250 m3_n3682_n13924# VSUBS 0.02819f
C2251 m3_n3794_n13924# VSUBS 0.00826f
C2252 m3_n3906_n13924# VSUBS 0.02819f
C2253 m3_n3682_n13812# VSUBS 0.02819f
C2254 m3_n3794_n13812# VSUBS 0.00826f
C2255 m3_n3906_n13812# VSUBS 0.02819f
C2256 m3_n3682_n13700# VSUBS 0.02819f
C2257 m3_n3794_n13700# VSUBS 0.00826f
C2258 m3_n3906_n13700# VSUBS 0.02819f
C2259 m3_n3682_n13588# VSUBS 0.02819f
C2260 m3_n3794_n13588# VSUBS 0.00826f
C2261 m3_n3906_n13588# VSUBS 0.02819f
C2262 m3_n3682_n13476# VSUBS 0.02819f
C2263 m3_n3794_n13476# VSUBS 0.00826f
C2264 m3_n3906_n13476# VSUBS 0.02819f
C2265 m3_n3682_n13364# VSUBS 0.02819f
C2266 m3_n3794_n13364# VSUBS 0.00826f
C2267 m3_n3906_n13364# VSUBS 0.02819f
C2268 m3_n3682_n13252# VSUBS 0.02819f
C2269 m3_n3794_n13252# VSUBS 0.00826f
C2270 m3_n3906_n13252# VSUBS 0.02819f
C2271 m3_n3682_n13140# VSUBS 0.02819f
C2272 m3_n3794_n13140# VSUBS 0.00826f
C2273 m3_n3906_n13140# VSUBS 0.02819f
C2274 m3_n3682_n13028# VSUBS 0.02819f
C2275 m3_n3794_n13028# VSUBS 0.00826f
C2276 m3_n3906_n13028# VSUBS 0.02819f
C2277 m3_n3682_n12916# VSUBS 0.02819f
C2278 m3_n3794_n12916# VSUBS 0.00826f
C2279 m3_n3906_n12916# VSUBS 0.02819f
C2280 m3_n3682_n12804# VSUBS 0.02819f
C2281 m3_n3794_n12804# VSUBS 0.00826f
C2282 m3_n3906_n12804# VSUBS 0.02819f
C2283 m3_n3682_n12692# VSUBS 0.02819f
C2284 m3_n3794_n12692# VSUBS 0.00826f
C2285 m3_n3906_n12692# VSUBS 0.02819f
C2286 m3_n3682_n12580# VSUBS 0.02819f
C2287 m3_n3794_n12580# VSUBS 0.00826f
C2288 m3_n3906_n12580# VSUBS 0.02819f
C2289 m3_n3682_n12468# VSUBS 0.02819f
C2290 m3_n3794_n12468# VSUBS 0.00826f
C2291 m3_n3906_n12468# VSUBS 0.02819f
C2292 m3_n3682_n12356# VSUBS 0.02819f
C2293 m3_n3794_n12356# VSUBS 0.00826f
C2294 m3_n3906_n12356# VSUBS 0.02819f
C2295 m3_n3682_n12244# VSUBS 0.02819f
C2296 m3_n3794_n12244# VSUBS 0.00826f
C2297 m3_n3906_n12244# VSUBS 0.02819f
C2298 m3_n3682_n12132# VSUBS 0.02819f
C2299 m3_n3794_n12132# VSUBS 0.00826f
C2300 m3_n3906_n12132# VSUBS 0.02819f
C2301 m3_n3682_n12020# VSUBS 0.02819f
C2302 m3_n3794_n12020# VSUBS 0.00826f
C2303 m3_n3906_n12020# VSUBS 0.02819f
C2304 m3_n3682_n11908# VSUBS 0.02819f
C2305 m3_n3794_n11908# VSUBS 0.00826f
C2306 m3_n3906_n11908# VSUBS 0.02819f
C2307 m3_n3682_n11796# VSUBS 0.02819f
C2308 m3_n3794_n11796# VSUBS 0.00826f
C2309 m3_n3906_n11796# VSUBS 0.02819f
C2310 m3_n3682_n11684# VSUBS 0.02819f
C2311 m3_n3794_n11684# VSUBS 0.00826f
C2312 m3_n3906_n11684# VSUBS 0.02819f
C2313 m3_n3682_n11572# VSUBS 0.02819f
C2314 m3_n3794_n11572# VSUBS 0.00826f
C2315 m3_n3906_n11572# VSUBS 0.02819f
C2316 m3_n3682_n11460# VSUBS 0.02819f
C2317 m3_n3794_n11460# VSUBS 0.00826f
C2318 m3_n3906_n11460# VSUBS 0.02819f
C2319 m3_n3682_n11348# VSUBS 0.02819f
C2320 m3_n3794_n11348# VSUBS 0.00826f
C2321 m3_n3906_n11348# VSUBS 0.02819f
C2322 m3_n3682_n11236# VSUBS 0.02819f
C2323 m3_n3794_n11236# VSUBS 0.00826f
C2324 m3_n3906_n11236# VSUBS 0.02819f
C2325 m3_n3682_n11124# VSUBS 0.02819f
C2326 m3_n3794_n11124# VSUBS 0.00826f
C2327 m3_n3906_n11124# VSUBS 0.02819f
C2328 m3_n3682_n11012# VSUBS 0.02819f
C2329 m3_n3794_n11012# VSUBS 0.00826f
C2330 m3_n3906_n11012# VSUBS 0.02819f
C2331 m3_n3682_n10900# VSUBS 0.02819f
C2332 m3_n3794_n10900# VSUBS 0.00826f
C2333 m3_n3906_n10900# VSUBS 0.02819f
C2334 m3_n3682_n10788# VSUBS 0.02819f
C2335 m3_n3794_n10788# VSUBS 0.00826f
C2336 m3_n3906_n10788# VSUBS 0.02819f
C2337 m3_n3682_n10676# VSUBS 0.02819f
C2338 m3_n3794_n10676# VSUBS 0.00826f
C2339 m3_n3906_n10676# VSUBS 0.02819f
C2340 m3_n3682_n10564# VSUBS 0.02819f
C2341 m3_n3794_n10564# VSUBS 0.00826f
C2342 m3_n3906_n10564# VSUBS 0.02819f
C2343 m3_n3682_n10452# VSUBS 0.02819f
C2344 m3_n3794_n10452# VSUBS 0.00826f
C2345 m3_n3906_n10452# VSUBS 0.02819f
C2346 m3_n3682_n10340# VSUBS 0.02819f
C2347 m3_n3794_n10340# VSUBS 0.00826f
C2348 m3_n3906_n10340# VSUBS 0.02819f
C2349 m3_n3682_n10228# VSUBS 0.02819f
C2350 m3_n3794_n10228# VSUBS 0.00826f
C2351 m3_n3906_n10228# VSUBS 0.02819f
C2352 m3_n3682_n10116# VSUBS 0.02819f
C2353 m3_n3794_n10116# VSUBS 0.00826f
C2354 m3_n3906_n10116# VSUBS 0.02819f
C2355 m3_n3682_n10004# VSUBS 0.02819f
C2356 m3_n3794_n10004# VSUBS 0.00826f
C2357 m3_n3906_n10004# VSUBS 0.02819f
C2358 m3_n3682_n9892# VSUBS 0.02819f
C2359 m3_n3794_n9892# VSUBS 0.00826f
C2360 m3_n3906_n9892# VSUBS 0.02819f
C2361 m3_n3682_n9780# VSUBS 0.02819f
C2362 m3_n3794_n9780# VSUBS 0.00826f
C2363 m3_n3906_n9780# VSUBS 0.02819f
C2364 m3_n3682_n9668# VSUBS 0.02819f
C2365 m3_n3794_n9668# VSUBS 0.00826f
C2366 m3_n3906_n9668# VSUBS 0.02819f
C2367 m3_n3682_n9556# VSUBS 0.02819f
C2368 m3_n3794_n9556# VSUBS 0.00826f
C2369 m3_n3906_n9556# VSUBS 0.02819f
C2370 m3_n3682_n9444# VSUBS 0.02819f
C2371 m3_n3794_n9444# VSUBS 0.00826f
C2372 m3_n3906_n9444# VSUBS 0.02819f
C2373 m3_n3682_n9332# VSUBS 0.02819f
C2374 m3_n3794_n9332# VSUBS 0.00826f
C2375 m3_n3906_n9332# VSUBS 0.02819f
C2376 m3_n3682_n9220# VSUBS 0.02819f
C2377 m3_n3794_n9220# VSUBS 0.00826f
C2378 m3_n3906_n9220# VSUBS 0.02819f
C2379 m3_n3682_n9108# VSUBS 0.02819f
C2380 m3_n3794_n9108# VSUBS 0.00826f
C2381 m3_n3906_n9108# VSUBS 0.02819f
C2382 m3_n3682_n8996# VSUBS 0.02819f
C2383 m3_n3794_n8996# VSUBS 0.00826f
C2384 m3_n3906_n8996# VSUBS 0.02819f
C2385 m3_n3682_n8884# VSUBS 0.02819f
C2386 m3_n3794_n8884# VSUBS 0.00826f
C2387 m3_n3906_n8884# VSUBS 0.02819f
C2388 m3_n3682_n8772# VSUBS 0.02819f
C2389 m3_n3794_n8772# VSUBS 0.00826f
C2390 m3_n3906_n8772# VSUBS 0.02819f
C2391 m3_n3682_n8660# VSUBS 0.02819f
C2392 m3_n3794_n8660# VSUBS 0.00826f
C2393 m3_n3906_n8660# VSUBS 0.02819f
C2394 m3_n3682_n8548# VSUBS 0.02819f
C2395 m3_n3794_n8548# VSUBS 0.00826f
C2396 m3_n3906_n8548# VSUBS 0.02819f
C2397 m3_n3682_n8436# VSUBS 0.02819f
C2398 m3_n3794_n8436# VSUBS 0.00826f
C2399 m3_n3906_n8436# VSUBS 0.02819f
C2400 m3_n3682_n8324# VSUBS 0.02819f
C2401 m3_n3794_n8324# VSUBS 0.00826f
C2402 m3_n3906_n8324# VSUBS 0.02819f
C2403 m3_n3682_n8212# VSUBS 0.02819f
C2404 m3_n3794_n8212# VSUBS 0.00826f
C2405 m3_n3906_n8212# VSUBS 0.02819f
C2406 m3_n3682_n8100# VSUBS 0.02819f
C2407 m3_n3794_n8100# VSUBS 0.00826f
C2408 m3_n3906_n8100# VSUBS 0.02819f
C2409 m3_n3682_n7988# VSUBS 0.02819f
C2410 m3_n3794_n7988# VSUBS 0.00826f
C2411 m3_n3906_n7988# VSUBS 0.02819f
C2412 m3_n3682_n7876# VSUBS 0.02819f
C2413 m3_n3794_n7876# VSUBS 0.00826f
C2414 m3_n3906_n7876# VSUBS 0.02819f
C2415 m3_n3682_n7764# VSUBS 0.02819f
C2416 m3_n3794_n7764# VSUBS 0.00826f
C2417 m3_n3906_n7764# VSUBS 0.02819f
C2418 m3_n3682_n7652# VSUBS 0.02819f
C2419 m3_n3794_n7652# VSUBS 0.00826f
C2420 m3_n3906_n7652# VSUBS 0.02819f
C2421 m3_n3682_n7540# VSUBS 0.02819f
C2422 m3_n3794_n7540# VSUBS 0.00826f
C2423 m3_n3906_n7540# VSUBS 0.02819f
C2424 m3_n3682_n7428# VSUBS 0.02819f
C2425 m3_n3794_n7428# VSUBS 0.00826f
C2426 m3_n3906_n7428# VSUBS 0.02819f
C2427 m3_n3682_n7316# VSUBS 0.02819f
C2428 m3_n3794_n7316# VSUBS 0.00826f
C2429 m3_n3906_n7316# VSUBS 0.02819f
C2430 m3_n3682_n7204# VSUBS 0.02819f
C2431 m3_n3794_n7204# VSUBS 0.00826f
C2432 m3_n3906_n7204# VSUBS 0.02819f
C2433 m3_n3682_n7092# VSUBS 0.02819f
C2434 m3_n3794_n7092# VSUBS 0.00826f
C2435 m3_n3906_n7092# VSUBS 0.02819f
C2436 m3_n3682_n6980# VSUBS 0.02819f
C2437 m3_n3794_n6980# VSUBS 0.00826f
C2438 m3_n3906_n6980# VSUBS 0.02819f
C2439 m3_n3682_n6868# VSUBS 0.02819f
C2440 m3_n3794_n6868# VSUBS 0.00826f
C2441 m3_n3906_n6868# VSUBS 0.02819f
C2442 m3_n3682_n6756# VSUBS 0.02819f
C2443 m3_n3794_n6756# VSUBS 0.00826f
C2444 m3_n3906_n6756# VSUBS 0.02819f
C2445 m3_n3682_n6644# VSUBS 0.02819f
C2446 m3_n3794_n6644# VSUBS 0.00826f
C2447 m3_n3906_n6644# VSUBS 0.02819f
C2448 m3_n3682_n6532# VSUBS 0.02819f
C2449 m3_n3794_n6532# VSUBS 0.00826f
C2450 m3_n3906_n6532# VSUBS 0.02819f
C2451 m3_n3682_n6420# VSUBS 0.02819f
C2452 m3_n3794_n6420# VSUBS 0.00826f
C2453 m3_n3906_n6420# VSUBS 0.02819f
C2454 m3_n3682_n6308# VSUBS 0.01443f
C2455 m3_n3794_n6308# VSUBS 0.00826f
C2456 m3_n3906_n6308# VSUBS 0.02819f
C2457 m3_n3682_n6196# VSUBS 0.01443f
C2458 m3_n3794_n6196# VSUBS 0.00826f
C2459 m3_n3906_n6196# VSUBS 0.02819f
C2460 m3_n3682_n6084# VSUBS 0.01443f
C2461 m3_n3794_n6084# VSUBS 0.00826f
C2462 m3_n3906_n6084# VSUBS 0.02819f
C2463 m3_n3682_n5972# VSUBS 0.01443f
C2464 m3_n3794_n5972# VSUBS 0.00826f
C2465 m3_n3906_n5972# VSUBS 0.02819f
C2466 m3_n3682_n5860# VSUBS 0.01443f
C2467 m3_n3794_n5860# VSUBS 0.00826f
C2468 m3_n3906_n5860# VSUBS 0.02819f
C2469 m3_n3682_n5748# VSUBS 0.01443f
C2470 m3_n3794_n5748# VSUBS 0.00826f
C2471 m3_n3906_n5748# VSUBS 0.02819f
C2472 m3_n3682_n5636# VSUBS 0.01443f
C2473 m3_n3794_n5636# VSUBS 0.00826f
C2474 m3_n3906_n5636# VSUBS 0.02819f
C2475 m3_n3682_n5524# VSUBS 0.01443f
C2476 m3_n3794_n5524# VSUBS 0.00826f
C2477 m3_n3906_n5524# VSUBS 0.02819f
C2478 m3_n3682_n5412# VSUBS 0.01443f
C2479 m3_n3794_n5412# VSUBS 0.00826f
C2480 m3_n3906_n5412# VSUBS 0.02819f
C2481 m3_n3682_n5300# VSUBS 0.01443f
C2482 m3_n3794_n5300# VSUBS 0.00826f
C2483 m3_n3906_n5300# VSUBS 0.02819f
C2484 m3_n3682_n5188# VSUBS 0.01443f
C2485 m3_n3794_n5188# VSUBS 0.00826f
C2486 m3_n3906_n5188# VSUBS 0.02819f
C2487 m3_n3682_n5076# VSUBS 0.01443f
C2488 m3_n3794_n5076# VSUBS 0.00826f
C2489 m3_n3906_n5076# VSUBS 0.02819f
C2490 m3_n3682_n4964# VSUBS 0.01443f
C2491 m3_n3794_n4964# VSUBS 0.00826f
C2492 m3_n3906_n4964# VSUBS 0.02819f
C2493 m3_n3682_n4852# VSUBS 0.01443f
C2494 m3_n3794_n4852# VSUBS 0.00826f
C2495 m3_n3906_n4852# VSUBS 0.02819f
C2496 m3_n3682_n4740# VSUBS 0.01443f
C2497 m3_n3794_n4740# VSUBS 0.00826f
C2498 m3_n3906_n4740# VSUBS 0.02819f
C2499 m3_n3682_n4628# VSUBS 0.01443f
C2500 m3_n3794_n4628# VSUBS 0.00826f
C2501 m3_n3906_n4628# VSUBS 0.02819f
C2502 m3_n3682_n4516# VSUBS 0.01443f
C2503 m3_n3794_n4516# VSUBS 0.00826f
C2504 m3_n3906_n4516# VSUBS 0.02819f
C2505 m3_n3682_n4404# VSUBS 0.01443f
C2506 m3_n3794_n4404# VSUBS 0.00826f
C2507 m3_n3906_n4404# VSUBS 0.02819f
C2508 m3_n3682_n4292# VSUBS 0.01443f
C2509 m3_n3794_n4292# VSUBS 0.00826f
C2510 m3_n3906_n4292# VSUBS 0.02819f
C2511 m3_n3682_n4180# VSUBS 0.01443f
C2512 m3_n3794_n4180# VSUBS 0.00826f
C2513 m3_n3906_n4180# VSUBS 0.02819f
C2514 m3_n3682_n4068# VSUBS 0.01443f
C2515 m3_n3794_n4068# VSUBS 0.00826f
C2516 m3_n3906_n4068# VSUBS 0.02819f
C2517 m3_n3682_n3956# VSUBS 0.01443f
C2518 m3_n3794_n3956# VSUBS 0.00826f
C2519 m3_n3906_n3956# VSUBS 0.02819f
C2520 m3_n3682_n3844# VSUBS 0.01443f
C2521 m3_n3794_n3844# VSUBS 0.00826f
C2522 m3_n3906_n3844# VSUBS 0.02819f
C2523 m3_n3682_n3732# VSUBS 0.01443f
C2524 m3_n3794_n3732# VSUBS 0.00826f
C2525 m3_n3906_n3732# VSUBS 0.02819f
C2526 m3_n3682_n3620# VSUBS 0.01443f
C2527 m3_n3794_n3620# VSUBS 0.00826f
C2528 m3_n3906_n3620# VSUBS 0.02819f
C2529 m3_n3682_n3508# VSUBS 0.01443f
C2530 m3_n3794_n3508# VSUBS 0.00826f
C2531 m3_n3906_n3508# VSUBS 0.02819f
C2532 m3_n3682_n3396# VSUBS 0.01443f
C2533 m3_n3794_n3396# VSUBS 0.00826f
C2534 m3_n3906_n3396# VSUBS 0.02819f
C2535 m3_n3682_n3284# VSUBS 0.01443f
C2536 m3_n3794_n3284# VSUBS 0.00826f
C2537 m3_n3906_n3284# VSUBS 0.02819f
C2538 m3_n3682_n3172# VSUBS 0.01443f
C2539 m3_n3794_n3172# VSUBS 0.00826f
C2540 m3_n3906_n3172# VSUBS 0.02819f
C2541 m3_n3682_n3060# VSUBS 0.01443f
C2542 m3_n3794_n3060# VSUBS 0.00826f
C2543 m3_n3906_n3060# VSUBS 0.02819f
C2544 m3_n3682_n2948# VSUBS 0.01443f
C2545 m3_n3794_n2948# VSUBS 0.00826f
C2546 m3_n3906_n2948# VSUBS 0.02819f
C2547 m3_n3682_n2836# VSUBS 0.01443f
C2548 m3_n3794_n2836# VSUBS 0.00826f
C2549 m3_n3906_n2836# VSUBS 0.02819f
C2550 m3_n3682_n2724# VSUBS 0.01443f
C2551 m3_n3794_n2724# VSUBS 0.00826f
C2552 m3_n3906_n2724# VSUBS 0.02819f
C2553 m3_n3682_n2612# VSUBS 0.01443f
C2554 m3_n3794_n2612# VSUBS 0.00826f
C2555 m3_n3906_n2612# VSUBS 0.02819f
C2556 m3_n3682_n2500# VSUBS 0.01443f
C2557 m3_n3794_n2500# VSUBS 0.00826f
C2558 m3_n3906_n2500# VSUBS 0.02819f
C2559 m3_n3682_n2388# VSUBS 0.01443f
C2560 m3_n3794_n2388# VSUBS 0.00826f
C2561 m3_n3906_n2388# VSUBS 0.02819f
C2562 m3_n3682_n2276# VSUBS 0.01443f
C2563 m3_n3794_n2276# VSUBS 0.00826f
C2564 m3_n3906_n2276# VSUBS 0.02819f
C2565 m3_n3682_n2164# VSUBS 0.01443f
C2566 m3_n3794_n2164# VSUBS 0.00826f
C2567 m3_n3906_n2164# VSUBS 0.02819f
C2568 m3_n3682_n2052# VSUBS 0.01443f
C2569 m3_n3794_n2052# VSUBS 0.00826f
C2570 m3_n3906_n2052# VSUBS 0.02819f
C2571 m3_n3682_n1940# VSUBS 0.01443f
C2572 m3_n3794_n1940# VSUBS 0.00826f
C2573 m3_n3906_n1940# VSUBS 0.02819f
C2574 m3_n3682_n1828# VSUBS 0.01443f
C2575 m3_n3794_n1828# VSUBS 0.00826f
C2576 m3_n3906_n1828# VSUBS 0.02819f
C2577 m3_n3682_n1716# VSUBS 0.01443f
C2578 m3_n3794_n1716# VSUBS 0.00826f
C2579 m3_n3906_n1716# VSUBS 0.02819f
C2580 m3_n3682_n1604# VSUBS 0.01443f
C2581 m3_n3794_n1604# VSUBS 0.00826f
C2582 m3_n3906_n1604# VSUBS 0.02819f
C2583 m3_n3682_n1492# VSUBS 0.01443f
C2584 m3_n3794_n1492# VSUBS 0.00826f
C2585 m3_n3906_n1492# VSUBS 0.02819f
C2586 m3_n3682_n1380# VSUBS 0.01443f
C2587 m3_n3794_n1380# VSUBS 0.00826f
C2588 m3_n3906_n1380# VSUBS 0.02819f
C2589 m3_n3682_n1268# VSUBS 0.01443f
C2590 m3_n3794_n1268# VSUBS 0.00826f
C2591 m3_n3906_n1268# VSUBS 0.02819f
C2592 m3_n3682_n1156# VSUBS 0.01443f
C2593 m3_n3794_n1156# VSUBS 0.00826f
C2594 m3_n3906_n1156# VSUBS 0.02819f
C2595 m3_n3682_n1044# VSUBS 0.01443f
C2596 m3_n3794_n1044# VSUBS 0.00826f
C2597 m3_n3906_n1044# VSUBS 0.02819f
C2598 m3_n3682_n932# VSUBS 0.01443f
C2599 m3_n3794_n932# VSUBS 0.00826f
C2600 m3_n3906_n932# VSUBS 0.02819f
C2601 m3_n3682_n820# VSUBS 0.01443f
C2602 m3_n3794_n820# VSUBS 0.00826f
C2603 m3_n3906_n820# VSUBS 0.02819f
C2604 m3_n3682_n708# VSUBS 0.01443f
C2605 m3_n3794_n708# VSUBS 0.00826f
C2606 m3_n3906_n708# VSUBS 0.02819f
C2607 m3_n3682_n596# VSUBS 0.01443f
C2608 m3_n3794_n596# VSUBS 0.00826f
C2609 m3_n3906_n596# VSUBS 0.02819f
C2610 m3_n3682_n484# VSUBS 0.01443f
C2611 m3_n3794_n484# VSUBS 0.00826f
C2612 m3_n3906_n484# VSUBS 0.02819f
C2613 m3_n3682_n372# VSUBS 0.01443f
C2614 m3_n3794_n372# VSUBS 0.00826f
C2615 m3_n3906_n372# VSUBS 0.02819f
C2616 m3_n3682_n260# VSUBS 0.01443f
C2617 m3_n3794_n260# VSUBS 0.00826f
C2618 m3_n3906_n260# VSUBS 0.02819f
C2619 m3_n3682_n148# VSUBS 0.01443f
C2620 m3_n3794_n148# VSUBS 0.00826f
C2621 m3_n3906_n148# VSUBS 0.02819f
C2622 m3_n3682_n36# VSUBS 0.01443f
C2623 m3_n3794_n36# VSUBS 0.00826f
C2624 m3_n3906_n36# VSUBS 0.02819f
C2625 m3_n3682_76# VSUBS 0.01443f
C2626 m3_n3794_76# VSUBS 0.00826f
C2627 m3_n3906_76# VSUBS 0.02819f
C2628 m3_n3682_188# VSUBS 0.01443f
C2629 m3_n3794_188# VSUBS 0.00826f
C2630 m3_n3906_188# VSUBS 0.02819f
C2631 m3_n3682_300# VSUBS 0.01443f
C2632 m3_n3794_300# VSUBS 0.00826f
C2633 m3_n3906_300# VSUBS 0.02819f
C2634 m3_n3682_412# VSUBS 0.01443f
C2635 m3_n3794_412# VSUBS 0.00826f
C2636 m3_n3906_412# VSUBS 0.02819f
C2637 m3_n3682_524# VSUBS 0.01443f
C2638 m3_n3794_524# VSUBS 0.00826f
C2639 m3_n3906_524# VSUBS 0.02819f
C2640 m3_n3682_636# VSUBS 0.01443f
C2641 m3_n3794_636# VSUBS 0.00826f
C2642 m3_n3906_636# VSUBS 0.02819f
C2643 m3_n3682_748# VSUBS 0.01443f
C2644 m3_n3794_748# VSUBS 0.00826f
C2645 m3_n3906_748# VSUBS 0.02819f
C2646 m3_n3682_860# VSUBS 0.01443f
C2647 m3_n3794_860# VSUBS 0.00826f
C2648 m3_n3906_860# VSUBS 0.02819f
C2649 m3_n3682_972# VSUBS 0.01443f
C2650 m3_n3794_972# VSUBS 0.00826f
C2651 m3_n3906_972# VSUBS 0.02819f
C2652 m3_n3682_1084# VSUBS 0.01443f
C2653 m3_n3794_1084# VSUBS 0.00826f
C2654 m3_n3906_1084# VSUBS 0.02819f
C2655 m3_n3682_1196# VSUBS 0.01443f
C2656 m3_n3794_1196# VSUBS 0.00826f
C2657 m3_n3906_1196# VSUBS 0.02819f
C2658 m3_n3682_1308# VSUBS 0.01443f
C2659 m3_n3794_1308# VSUBS 0.00826f
C2660 m3_n3906_1308# VSUBS 0.02819f
C2661 m3_n3682_1420# VSUBS 0.01443f
C2662 m3_n3794_1420# VSUBS 0.00826f
C2663 m3_n3906_1420# VSUBS 0.02819f
C2664 m3_n3682_1532# VSUBS 0.01443f
C2665 m3_n3794_1532# VSUBS 0.00826f
C2666 m3_n3906_1532# VSUBS 0.02819f
C2667 m3_n3682_1644# VSUBS 0.01443f
C2668 m3_n3794_1644# VSUBS 0.00826f
C2669 m3_n3906_1644# VSUBS 0.02819f
C2670 m3_n3682_1756# VSUBS 0.01443f
C2671 m3_n3794_1756# VSUBS 0.00826f
C2672 m3_n3906_1756# VSUBS 0.02819f
C2673 m3_n3682_1868# VSUBS 0.01443f
C2674 m3_n3794_1868# VSUBS 0.00826f
C2675 m3_n3906_1868# VSUBS 0.02819f
C2676 m3_n3682_1980# VSUBS 0.01443f
C2677 m3_n3794_1980# VSUBS 0.00826f
C2678 m3_n3906_1980# VSUBS 0.02819f
C2679 m3_n3682_2092# VSUBS 0.01443f
C2680 m3_n3794_2092# VSUBS 0.00826f
C2681 m3_n3906_2092# VSUBS 0.02819f
C2682 m3_n3682_2204# VSUBS 0.01443f
C2683 m3_n3794_2204# VSUBS 0.00826f
C2684 m3_n3906_2204# VSUBS 0.02819f
C2685 m3_n3682_2316# VSUBS 0.01443f
C2686 m3_n3794_2316# VSUBS 0.00826f
C2687 m3_n3906_2316# VSUBS 0.02819f
C2688 m3_n3682_2428# VSUBS 0.01443f
C2689 m3_n3794_2428# VSUBS 0.00826f
C2690 m3_n3906_2428# VSUBS 0.02819f
C2691 m3_n3682_2540# VSUBS 0.01443f
C2692 m3_n3794_2540# VSUBS 0.00826f
C2693 m3_n3906_2540# VSUBS 0.02819f
C2694 m3_n3682_2652# VSUBS 0.01443f
C2695 m3_n3794_2652# VSUBS 0.00826f
C2696 m3_n3906_2652# VSUBS 0.02819f
C2697 m3_n3682_2764# VSUBS 0.01443f
C2698 m3_n3794_2764# VSUBS 0.00826f
C2699 m3_n3906_2764# VSUBS 0.02819f
C2700 m3_n3682_2876# VSUBS 0.01443f
C2701 m3_n3794_2876# VSUBS 0.00826f
C2702 m3_n3906_2876# VSUBS 0.02819f
C2703 m3_n3682_2988# VSUBS 0.01443f
C2704 m3_n3794_2988# VSUBS 0.00826f
C2705 m3_n3906_2988# VSUBS 0.02819f
C2706 m3_n3682_3100# VSUBS 0.01443f
C2707 m3_n3794_3100# VSUBS 0.00826f
C2708 m3_n3906_3100# VSUBS 0.02819f
C2709 m3_n3682_3212# VSUBS 0.01443f
C2710 m3_n3794_3212# VSUBS 0.00826f
C2711 m3_n3906_3212# VSUBS 0.02819f
C2712 m3_n3682_3324# VSUBS 0.01443f
C2713 m3_n3794_3324# VSUBS 0.00826f
C2714 m3_n3906_3324# VSUBS 0.02819f
C2715 m3_n3682_3436# VSUBS 0.01443f
C2716 m3_n3794_3436# VSUBS 0.00826f
C2717 m3_n3906_3436# VSUBS 0.02819f
C2718 m3_n3682_3548# VSUBS 0.01443f
C2719 m3_n3794_3548# VSUBS 0.00826f
C2720 m3_n3906_3548# VSUBS 0.02819f
C2721 m3_n3682_3660# VSUBS 0.01443f
C2722 m3_n3794_3660# VSUBS 0.00826f
C2723 m3_n3906_3660# VSUBS 0.02819f
C2724 m3_n3682_3772# VSUBS 0.01443f
C2725 m3_n3794_3772# VSUBS 0.00826f
C2726 m3_n3906_3772# VSUBS 0.02819f
C2727 m3_n3682_3884# VSUBS 0.01443f
C2728 m3_n3794_3884# VSUBS 0.00826f
C2729 m3_n3906_3884# VSUBS 0.02819f
C2730 m3_n3682_3996# VSUBS 0.01443f
C2731 m3_n3794_3996# VSUBS 0.00826f
C2732 m3_n3906_3996# VSUBS 0.02819f
C2733 m3_n3682_4108# VSUBS 0.01443f
C2734 m3_n3794_4108# VSUBS 0.00826f
C2735 m3_n3906_4108# VSUBS 0.02819f
C2736 m3_n3682_4220# VSUBS 0.01443f
C2737 m3_n3794_4220# VSUBS 0.00826f
C2738 m3_n3906_4220# VSUBS 0.02819f
C2739 m3_n3682_4332# VSUBS 0.01443f
C2740 m3_n3794_4332# VSUBS 0.00826f
C2741 m3_n3906_4332# VSUBS 0.02819f
C2742 m3_n3682_4444# VSUBS 0.01443f
C2743 m3_n3794_4444# VSUBS 0.00826f
C2744 m3_n3906_4444# VSUBS 0.02819f
C2745 m3_n3682_4556# VSUBS 0.01443f
C2746 m3_n3794_4556# VSUBS 0.00826f
C2747 m3_n3906_4556# VSUBS 0.02819f
C2748 m3_n3682_4668# VSUBS 0.01443f
C2749 m3_n3794_4668# VSUBS 0.00826f
C2750 m3_n3906_4668# VSUBS 0.02819f
C2751 m3_n3682_4780# VSUBS 0.01443f
C2752 m3_n3794_4780# VSUBS 0.00826f
C2753 m3_n3906_4780# VSUBS 0.02819f
C2754 m3_n3682_4892# VSUBS 0.01443f
C2755 m3_n3794_4892# VSUBS 0.00826f
C2756 m3_n3906_4892# VSUBS 0.02819f
C2757 m3_n3682_5004# VSUBS 0.01443f
C2758 m3_n3794_5004# VSUBS 0.00826f
C2759 m3_n3906_5004# VSUBS 0.02819f
C2760 m3_n3682_5116# VSUBS 0.01443f
C2761 m3_n3794_5116# VSUBS 0.00826f
C2762 m3_n3906_5116# VSUBS 0.02819f
C2763 m3_n3682_5228# VSUBS 0.01443f
C2764 m3_n3794_5228# VSUBS 0.00826f
C2765 m3_n3906_5228# VSUBS 0.02819f
C2766 m3_n3682_5340# VSUBS 0.01443f
C2767 m3_n3794_5340# VSUBS 0.00826f
C2768 m3_n3906_5340# VSUBS 0.02819f
C2769 m3_n3682_5452# VSUBS 0.01443f
C2770 m3_n3794_5452# VSUBS 0.00826f
C2771 m3_n3906_5452# VSUBS 0.02819f
C2772 m3_n3682_5564# VSUBS 0.01443f
C2773 m3_n3794_5564# VSUBS 0.00826f
C2774 m3_n3906_5564# VSUBS 0.02819f
C2775 m3_n3682_5676# VSUBS 0.01443f
C2776 m3_n3794_5676# VSUBS 0.00826f
C2777 m3_n3906_5676# VSUBS 0.02819f
C2778 m3_n3682_5788# VSUBS 0.01443f
C2779 m3_n3794_5788# VSUBS 0.00826f
C2780 m3_n3906_5788# VSUBS 0.02819f
C2781 m3_n3682_5900# VSUBS 0.01443f
C2782 m3_n3794_5900# VSUBS 0.00826f
C2783 m3_n3906_5900# VSUBS 0.02819f
C2784 m3_n3682_6012# VSUBS 0.02819f
C2785 m3_n3794_6012# VSUBS 0.00826f
C2786 m3_n3906_6012# VSUBS 0.02819f
C2787 m3_n3682_6124# VSUBS 0.02819f
C2788 m3_n3794_6124# VSUBS 0.00826f
C2789 m3_n3906_6124# VSUBS 0.02819f
C2790 m3_n3682_6236# VSUBS 0.02819f
C2791 m3_n3794_6236# VSUBS 0.00826f
C2792 m3_n3906_6236# VSUBS 0.02819f
C2793 m3_n3682_6348# VSUBS 0.02819f
C2794 m3_n3794_6348# VSUBS 0.00826f
C2795 m3_n3906_6348# VSUBS 0.02819f
C2796 m3_n3682_6460# VSUBS 0.02819f
C2797 m3_n3794_6460# VSUBS 0.00826f
C2798 m3_n3906_6460# VSUBS 0.02819f
C2799 m3_n3682_6572# VSUBS 0.02819f
C2800 m3_n3794_6572# VSUBS 0.00826f
C2801 m3_n3906_6572# VSUBS 0.02819f
C2802 m3_n3682_6684# VSUBS 0.02819f
C2803 m3_n3794_6684# VSUBS 0.00826f
C2804 m3_n3906_6684# VSUBS 0.02819f
C2805 m3_n3682_6796# VSUBS 0.02819f
C2806 m3_n3794_6796# VSUBS 0.00826f
C2807 m3_n3906_6796# VSUBS 0.02819f
C2808 m3_n3682_6908# VSUBS 0.02819f
C2809 m3_n3794_6908# VSUBS 0.00826f
C2810 m3_n3906_6908# VSUBS 0.02819f
C2811 m3_n3682_7020# VSUBS 0.02819f
C2812 m3_n3794_7020# VSUBS 0.00826f
C2813 m3_n3906_7020# VSUBS 0.02819f
C2814 m3_n3682_7132# VSUBS 0.02819f
C2815 m3_n3794_7132# VSUBS 0.00826f
C2816 m3_n3906_7132# VSUBS 0.02819f
C2817 m3_n3682_7244# VSUBS 0.02819f
C2818 m3_n3794_7244# VSUBS 0.00826f
C2819 m3_n3906_7244# VSUBS 0.02819f
C2820 m3_n3682_7356# VSUBS 0.02819f
C2821 m3_n3794_7356# VSUBS 0.00826f
C2822 m3_n3906_7356# VSUBS 0.02819f
C2823 m3_n3682_7468# VSUBS 0.02819f
C2824 m3_n3794_7468# VSUBS 0.00826f
C2825 m3_n3906_7468# VSUBS 0.02819f
C2826 m3_n3682_7580# VSUBS 0.02819f
C2827 m3_n3794_7580# VSUBS 0.00826f
C2828 m3_n3906_7580# VSUBS 0.02819f
C2829 m3_n3682_7692# VSUBS 0.02819f
C2830 m3_n3794_7692# VSUBS 0.00826f
C2831 m3_n3906_7692# VSUBS 0.02819f
C2832 m3_n3682_7804# VSUBS 0.02819f
C2833 m3_n3794_7804# VSUBS 0.00826f
C2834 m3_n3906_7804# VSUBS 0.02819f
C2835 m3_n3682_7916# VSUBS 0.02819f
C2836 m3_n3794_7916# VSUBS 0.00826f
C2837 m3_n3906_7916# VSUBS 0.02819f
C2838 m3_n3682_8028# VSUBS 0.02819f
C2839 m3_n3794_8028# VSUBS 0.00826f
C2840 m3_n3906_8028# VSUBS 0.02819f
C2841 m3_n3682_8140# VSUBS 0.02819f
C2842 m3_n3794_8140# VSUBS 0.00826f
C2843 m3_n3906_8140# VSUBS 0.02819f
C2844 m3_n3682_8252# VSUBS 0.02819f
C2845 m3_n3794_8252# VSUBS 0.00826f
C2846 m3_n3906_8252# VSUBS 0.02819f
C2847 m3_n3682_8364# VSUBS 0.02819f
C2848 m3_n3794_8364# VSUBS 0.00826f
C2849 m3_n3906_8364# VSUBS 0.02819f
C2850 m3_n3682_8476# VSUBS 0.02819f
C2851 m3_n3794_8476# VSUBS 0.00826f
C2852 m3_n3906_8476# VSUBS 0.02819f
C2853 m3_n3682_8588# VSUBS 0.02819f
C2854 m3_n3794_8588# VSUBS 0.00826f
C2855 m3_n3906_8588# VSUBS 0.02819f
C2856 m3_n3682_8700# VSUBS 0.02819f
C2857 m3_n3794_8700# VSUBS 0.00826f
C2858 m3_n3906_8700# VSUBS 0.02819f
C2859 m3_n3682_8812# VSUBS 0.02819f
C2860 m3_n3794_8812# VSUBS 0.00826f
C2861 m3_n3906_8812# VSUBS 0.02819f
C2862 m3_n3682_8924# VSUBS 0.02819f
C2863 m3_n3794_8924# VSUBS 0.00826f
C2864 m3_n3906_8924# VSUBS 0.02819f
C2865 m3_n3682_9036# VSUBS 0.02819f
C2866 m3_n3794_9036# VSUBS 0.00826f
C2867 m3_n3906_9036# VSUBS 0.02819f
C2868 m3_n3682_9148# VSUBS 0.02819f
C2869 m3_n3794_9148# VSUBS 0.00826f
C2870 m3_n3906_9148# VSUBS 0.02819f
C2871 m3_n3682_9260# VSUBS 0.02819f
C2872 m3_n3794_9260# VSUBS 0.00826f
C2873 m3_n3906_9260# VSUBS 0.02819f
C2874 m3_n3682_9372# VSUBS 0.02819f
C2875 m3_n3794_9372# VSUBS 0.00826f
C2876 m3_n3906_9372# VSUBS 0.02819f
C2877 m3_n3682_9484# VSUBS 0.02819f
C2878 m3_n3794_9484# VSUBS 0.00826f
C2879 m3_n3906_9484# VSUBS 0.02819f
C2880 m3_n3682_9596# VSUBS 0.02819f
C2881 m3_n3794_9596# VSUBS 0.00826f
C2882 m3_n3906_9596# VSUBS 0.02819f
C2883 m3_n3682_9708# VSUBS 0.02819f
C2884 m3_n3794_9708# VSUBS 0.00826f
C2885 m3_n3906_9708# VSUBS 0.02819f
C2886 m3_n3682_9820# VSUBS 0.02819f
C2887 m3_n3794_9820# VSUBS 0.00826f
C2888 m3_n3906_9820# VSUBS 0.02819f
C2889 m3_n3682_9932# VSUBS 0.02819f
C2890 m3_n3794_9932# VSUBS 0.00826f
C2891 m3_n3906_9932# VSUBS 0.02819f
C2892 m3_n3682_10044# VSUBS 0.02819f
C2893 m3_n3794_10044# VSUBS 0.00826f
C2894 m3_n3906_10044# VSUBS 0.02819f
C2895 m3_n3682_10156# VSUBS 0.02819f
C2896 m3_n3794_10156# VSUBS 0.00826f
C2897 m3_n3906_10156# VSUBS 0.02819f
C2898 m3_n3682_10268# VSUBS 0.02819f
C2899 m3_n3794_10268# VSUBS 0.00826f
C2900 m3_n3906_10268# VSUBS 0.02819f
C2901 m3_n3682_10380# VSUBS 0.02819f
C2902 m3_n3794_10380# VSUBS 0.00826f
C2903 m3_n3906_10380# VSUBS 0.02819f
C2904 m3_n3682_10492# VSUBS 0.02819f
C2905 m3_n3794_10492# VSUBS 0.00826f
C2906 m3_n3906_10492# VSUBS 0.02819f
C2907 m3_n3682_10604# VSUBS 0.02819f
C2908 m3_n3794_10604# VSUBS 0.00826f
C2909 m3_n3906_10604# VSUBS 0.02819f
C2910 m3_n3682_10716# VSUBS 0.02819f
C2911 m3_n3794_10716# VSUBS 0.00826f
C2912 m3_n3906_10716# VSUBS 0.02819f
C2913 m3_n3682_10828# VSUBS 0.02819f
C2914 m3_n3794_10828# VSUBS 0.00826f
C2915 m3_n3906_10828# VSUBS 0.02819f
C2916 m3_n3682_10940# VSUBS 0.02819f
C2917 m3_n3794_10940# VSUBS 0.00826f
C2918 m3_n3906_10940# VSUBS 0.02819f
C2919 m3_n3682_11052# VSUBS 0.02819f
C2920 m3_n3794_11052# VSUBS 0.00826f
C2921 m3_n3906_11052# VSUBS 0.02819f
C2922 m3_n3682_11164# VSUBS 0.02819f
C2923 m3_n3794_11164# VSUBS 0.00826f
C2924 m3_n3906_11164# VSUBS 0.02819f
C2925 m3_n3682_11276# VSUBS 0.02819f
C2926 m3_n3794_11276# VSUBS 0.00826f
C2927 m3_n3906_11276# VSUBS 0.02819f
C2928 m3_n3682_11388# VSUBS 0.02819f
C2929 m3_n3794_11388# VSUBS 0.00826f
C2930 m3_n3906_11388# VSUBS 0.02819f
C2931 m3_n3682_11500# VSUBS 0.02819f
C2932 m3_n3794_11500# VSUBS 0.00826f
C2933 m3_n3906_11500# VSUBS 0.02819f
C2934 m3_n3682_11612# VSUBS 0.02819f
C2935 m3_n3794_11612# VSUBS 0.00826f
C2936 m3_n3906_11612# VSUBS 0.02819f
C2937 m3_n3682_11724# VSUBS 0.02819f
C2938 m3_n3794_11724# VSUBS 0.00826f
C2939 m3_n3906_11724# VSUBS 0.02819f
C2940 m3_n3682_11836# VSUBS 0.02819f
C2941 m3_n3794_11836# VSUBS 0.00826f
C2942 m3_n3906_11836# VSUBS 0.02819f
C2943 m3_n3682_11948# VSUBS 0.02819f
C2944 m3_n3794_11948# VSUBS 0.00826f
C2945 m3_n3906_11948# VSUBS 0.02819f
C2946 m3_n3682_12060# VSUBS 0.02819f
C2947 m3_n3794_12060# VSUBS 0.00826f
C2948 m3_n3906_12060# VSUBS 0.02819f
C2949 m3_n3682_12172# VSUBS 0.02819f
C2950 m3_n3794_12172# VSUBS 0.00826f
C2951 m3_n3906_12172# VSUBS 0.02819f
C2952 m3_n3682_12284# VSUBS 0.02819f
C2953 m3_n3794_12284# VSUBS 0.00826f
C2954 m3_n3906_12284# VSUBS 0.02819f
C2955 m3_n3682_12396# VSUBS 0.02819f
C2956 m3_n3794_12396# VSUBS 0.00826f
C2957 m3_n3906_12396# VSUBS 0.02819f
C2958 m3_n3682_12508# VSUBS 0.02819f
C2959 m3_n3794_12508# VSUBS 0.00826f
C2960 m3_n3906_12508# VSUBS 0.02819f
C2961 m3_n3682_12620# VSUBS 0.02819f
C2962 m3_n3794_12620# VSUBS 0.00826f
C2963 m3_n3906_12620# VSUBS 0.02819f
C2964 m3_n3682_12732# VSUBS 0.02819f
C2965 m3_n3794_12732# VSUBS 0.00826f
C2966 m3_n3906_12732# VSUBS 0.02819f
C2967 m3_n3682_12844# VSUBS 0.02819f
C2968 m3_n3794_12844# VSUBS 0.00826f
C2969 m3_n3906_12844# VSUBS 0.02819f
C2970 m3_n3682_12956# VSUBS 0.02819f
C2971 m3_n3794_12956# VSUBS 0.00826f
C2972 m3_n3906_12956# VSUBS 0.02819f
C2973 m3_n3682_13068# VSUBS 0.02819f
C2974 m3_n3794_13068# VSUBS 0.00826f
C2975 m3_n3906_13068# VSUBS 0.02819f
C2976 m3_n3682_13180# VSUBS 0.02819f
C2977 m3_n3794_13180# VSUBS 0.00826f
C2978 m3_n3906_13180# VSUBS 0.02819f
C2979 m3_n3682_13292# VSUBS 0.02819f
C2980 m3_n3794_13292# VSUBS 0.00826f
C2981 m3_n3906_13292# VSUBS 0.02819f
C2982 m3_n3682_13404# VSUBS 0.02819f
C2983 m3_n3794_13404# VSUBS 0.00826f
C2984 m3_n3906_13404# VSUBS 0.02819f
C2985 m3_n3682_13516# VSUBS 0.02819f
C2986 m3_n3794_13516# VSUBS 0.00826f
C2987 m3_n3906_13516# VSUBS 0.02819f
C2988 m3_n3682_13628# VSUBS 0.02819f
C2989 m3_n3794_13628# VSUBS 0.00826f
C2990 m3_n3906_13628# VSUBS 0.02819f
C2991 m3_n3682_13740# VSUBS 0.02819f
C2992 m3_n3794_13740# VSUBS 0.00826f
C2993 m3_n3906_13740# VSUBS 0.02819f
C2994 m3_n3682_13852# VSUBS 0.02819f
C2995 m3_n3794_13852# VSUBS 0.00826f
C2996 m3_n3906_13852# VSUBS 0.02819f
C2997 m3_n3682_13964# VSUBS 0.02819f
C2998 m3_n3794_13964# VSUBS 0.00826f
C2999 m3_n3906_13964# VSUBS 0.02819f
C3000 m3_n3682_14076# VSUBS 0.02819f
C3001 m3_n3794_14076# VSUBS 0.00826f
C3002 m3_n3906_14076# VSUBS 0.02819f
C3003 m3_n3682_14188# VSUBS 0.02819f
C3004 m3_n3794_14188# VSUBS 0.00826f
C3005 m3_n3906_14188# VSUBS 0.02819f
C3006 m3_n3682_14300# VSUBS 0.02819f
C3007 m3_n3794_14300# VSUBS 0.00826f
C3008 m3_n3906_14300# VSUBS 0.02819f
C3009 m3_n3682_14412# VSUBS 0.02819f
C3010 m3_n3794_14412# VSUBS 0.00826f
C3011 m3_n3906_14412# VSUBS 0.02819f
C3012 m3_n3682_14524# VSUBS 0.02819f
C3013 m3_n3794_14524# VSUBS 0.00826f
C3014 m3_n3906_14524# VSUBS 0.02819f
C3015 m3_n3682_14636# VSUBS 0.02819f
C3016 m3_n3794_14636# VSUBS 0.00826f
C3017 m3_n3906_14636# VSUBS 0.02819f
C3018 m3_n3682_14748# VSUBS 0.02819f
C3019 m3_n3794_14748# VSUBS 0.00826f
C3020 m3_n3906_14748# VSUBS 0.02819f
C3021 m3_n3682_14860# VSUBS 0.02819f
C3022 m3_n3794_14860# VSUBS 0.00826f
C3023 m3_n3906_14860# VSUBS 0.02819f
C3024 m3_n3682_14972# VSUBS 0.02819f
C3025 m3_n3794_14972# VSUBS 0.00826f
C3026 m3_n3906_14972# VSUBS 0.02819f
C3027 m3_n3682_15084# VSUBS 0.02819f
C3028 m3_n3794_15084# VSUBS 0.00826f
C3029 m3_n3906_15084# VSUBS 0.02819f
C3030 m3_n3682_15196# VSUBS 0.02819f
C3031 m3_n3794_15196# VSUBS 0.00826f
C3032 m3_n3906_15196# VSUBS 0.02819f
C3033 m3_n3682_15308# VSUBS 0.02819f
C3034 m3_n3794_15308# VSUBS 0.00826f
C3035 m3_n3906_15308# VSUBS 0.02819f
C3036 m3_n3682_15420# VSUBS 0.02819f
C3037 m3_n3794_15420# VSUBS 0.00826f
C3038 m3_n3906_15420# VSUBS 0.02819f
C3039 m3_n3682_15532# VSUBS 0.02819f
C3040 m3_n3794_15532# VSUBS 0.00826f
C3041 m3_n3906_15532# VSUBS 0.02819f
C3042 m3_n3682_15644# VSUBS 0.02819f
C3043 m3_n3794_15644# VSUBS 0.00826f
C3044 m3_n3906_15644# VSUBS 0.02819f
C3045 m3_n3682_15756# VSUBS 0.02819f
C3046 m3_n3794_15756# VSUBS 0.00826f
C3047 m3_n3906_15756# VSUBS 0.02819f
C3048 m3_n3682_15868# VSUBS 0.02819f
C3049 m3_n3794_15868# VSUBS 0.00826f
C3050 m3_n3906_15868# VSUBS 0.02819f
C3051 m3_n3682_15980# VSUBS 0.02819f
C3052 m3_n3794_15980# VSUBS 0.00826f
C3053 m3_n3906_15980# VSUBS 0.02819f
C3054 m3_n3682_16092# VSUBS 0.02819f
C3055 m3_n3794_16092# VSUBS 0.00826f
C3056 m3_n3906_16092# VSUBS 0.02819f
C3057 m3_n3682_16204# VSUBS 0.02819f
C3058 m3_n3794_16204# VSUBS 0.00826f
C3059 m3_n3906_16204# VSUBS 0.02819f
C3060 m3_n3682_16316# VSUBS 0.02819f
C3061 m3_n3794_16316# VSUBS 0.00826f
C3062 m3_n3906_16316# VSUBS 0.02819f
C3063 m3_n3682_16428# VSUBS 0.02819f
C3064 m3_n3794_16428# VSUBS 0.00826f
C3065 m3_n3906_16428# VSUBS 0.02819f
C3066 m3_n3682_16540# VSUBS 0.02819f
C3067 m3_n3794_16540# VSUBS 0.00826f
C3068 m3_n3906_16540# VSUBS 0.02819f
C3069 m3_n3682_16652# VSUBS 0.02819f
C3070 m3_n3794_16652# VSUBS 0.00826f
C3071 m3_n3906_16652# VSUBS 0.02819f
C3072 m3_n3682_16764# VSUBS 0.02819f
C3073 m3_n3794_16764# VSUBS 0.00826f
C3074 m3_n3906_16764# VSUBS 0.02819f
C3075 m3_n3682_16876# VSUBS 0.02819f
C3076 m3_n3794_16876# VSUBS 0.00826f
C3077 m3_n3906_16876# VSUBS 0.02819f
C3078 m3_n3682_16988# VSUBS 0.02819f
C3079 m3_n3794_16988# VSUBS 0.00826f
C3080 m3_n3906_16988# VSUBS 0.02819f
C3081 m3_n3682_17100# VSUBS 0.02819f
C3082 m3_n3794_17100# VSUBS 0.00826f
C3083 m3_n3906_17100# VSUBS 0.02819f
C3084 m3_n3682_17212# VSUBS 0.02819f
C3085 m3_n3794_17212# VSUBS 0.00826f
C3086 m3_n3906_17212# VSUBS 0.02819f
C3087 m3_n3682_17324# VSUBS 0.02819f
C3088 m3_n3794_17324# VSUBS 0.00826f
C3089 m3_n3906_17324# VSUBS 0.02819f
C3090 m3_n3682_17436# VSUBS 0.02819f
C3091 m3_n3794_17436# VSUBS 0.00826f
C3092 m3_n3906_17436# VSUBS 0.02819f
C3093 m3_n3682_17548# VSUBS 0.02819f
C3094 m3_n3794_17548# VSUBS 0.00826f
C3095 m3_n3906_17548# VSUBS 0.02819f
C3096 m3_n3682_17660# VSUBS 0.02819f
C3097 m3_n3794_17660# VSUBS 0.00826f
C3098 m3_n3906_17660# VSUBS 0.02819f
C3099 m3_n3682_17772# VSUBS 0.02819f
C3100 m3_n3794_17772# VSUBS 0.00826f
C3101 m3_n3906_17772# VSUBS 0.02819f
C3102 m3_n3682_17884# VSUBS 0.02819f
C3103 m3_n3794_17884# VSUBS 0.00826f
C3104 m3_n3906_17884# VSUBS 0.02819f
C3105 m3_n3682_17996# VSUBS 0.02819f
C3106 m3_n3794_17996# VSUBS 0.00826f
C3107 m3_n3906_17996# VSUBS 0.02819f
C3108 m3_n3682_18108# VSUBS 0.02819f
C3109 m3_n3794_18108# VSUBS 0.00826f
C3110 m3_n3906_18108# VSUBS 0.02819f
C3111 m3_n3682_18220# VSUBS 0.02819f
C3112 m3_n3794_18220# VSUBS 0.00826f
C3113 m3_n3906_18220# VSUBS 0.02819f
C3114 m3_n3682_18332# VSUBS 0.02819f
C3115 m3_n3794_18332# VSUBS 0.00826f
C3116 m3_n3906_18332# VSUBS 0.02819f
C3117 m3_n3682_18444# VSUBS 0.02819f
C3118 m3_n3794_18444# VSUBS 0.00826f
C3119 m3_n3906_18444# VSUBS 0.02819f
C3120 m3_n3682_18556# VSUBS 0.02819f
C3121 m3_n3794_18556# VSUBS 0.00826f
C3122 m3_n3906_18556# VSUBS 0.02819f
C3123 m3_n3682_18668# VSUBS 0.02819f
C3124 m3_n3794_18668# VSUBS 0.00826f
C3125 m3_n3906_18668# VSUBS 0.02819f
C3126 m3_n3682_18780# VSUBS 0.02819f
C3127 m3_n3794_18780# VSUBS 0.00826f
C3128 m3_n3906_18780# VSUBS 0.02819f
C3129 m3_n3682_18892# VSUBS 0.02819f
C3130 m3_n3794_18892# VSUBS 0.00826f
C3131 m3_n3906_18892# VSUBS 0.02819f
C3132 m3_n3682_19004# VSUBS 0.02819f
C3133 m3_n3794_19004# VSUBS 0.00826f
C3134 m3_n3906_19004# VSUBS 0.02819f
C3135 m3_n3682_19116# VSUBS 0.02819f
C3136 m3_n3794_19116# VSUBS 0.00826f
C3137 m3_n3906_19116# VSUBS 0.02819f
C3138 m3_n3682_19228# VSUBS 0.02819f
C3139 m3_n3794_19228# VSUBS 0.00826f
C3140 m3_n3906_19228# VSUBS 0.02819f
C3141 m3_n3682_19340# VSUBS 0.02819f
C3142 m3_n3794_19340# VSUBS 0.00826f
C3143 m3_n3906_19340# VSUBS 0.02819f
C3144 m3_n3682_19452# VSUBS 0.02819f
C3145 m3_n3794_19452# VSUBS 0.00826f
C3146 m3_n3906_19452# VSUBS 0.02819f
C3147 m3_n3682_19564# VSUBS 0.02819f
C3148 m3_n3794_19564# VSUBS 0.00826f
C3149 m3_n3906_19564# VSUBS 0.02819f
C3150 m3_n3682_19676# VSUBS 0.02819f
C3151 m3_n3794_19676# VSUBS 0.00826f
C3152 m3_n3906_19676# VSUBS 0.02819f
C3153 m3_n3682_19788# VSUBS 0.02819f
C3154 m3_n3794_19788# VSUBS 0.00826f
C3155 m3_n3906_19788# VSUBS 0.02819f
C3156 m3_n3682_19900# VSUBS 0.02819f
C3157 m3_n3794_19900# VSUBS 0.00826f
C3158 m3_n3906_19900# VSUBS 0.02819f
C3159 m3_n3682_20012# VSUBS 0.02819f
C3160 m3_n3794_20012# VSUBS 0.00826f
C3161 m3_n3906_20012# VSUBS 0.02819f
C3162 m3_n3682_20124# VSUBS 0.02819f
C3163 m3_n3794_20124# VSUBS 0.00826f
C3164 m3_n3906_20124# VSUBS 0.02819f
C3165 m3_n3682_20236# VSUBS 0.02819f
C3166 m3_n3794_20236# VSUBS 0.00826f
C3167 m3_n3906_20236# VSUBS 0.02819f
C3168 m3_n3682_20348# VSUBS 0.02819f
C3169 m3_n3794_20348# VSUBS 0.00826f
C3170 m3_n3906_20348# VSUBS 0.02819f
C3171 m3_n3682_20460# VSUBS 0.02819f
C3172 m3_n3794_20460# VSUBS 0.00826f
C3173 m3_n3906_20460# VSUBS 0.02819f
C3174 m3_n3682_20572# VSUBS 0.02819f
C3175 m3_n3794_20572# VSUBS 0.00826f
C3176 m3_n3906_20572# VSUBS 0.02819f
C3177 m3_n3682_20684# VSUBS 0.02819f
C3178 m3_n3794_20684# VSUBS 0.00826f
C3179 m3_n3906_20684# VSUBS 0.02819f
C3180 m3_n3682_20796# VSUBS 0.02819f
C3181 m3_n3794_20796# VSUBS 0.00826f
C3182 m3_n3906_20796# VSUBS 0.02819f
C3183 m3_n3682_20908# VSUBS 0.02819f
C3184 m3_n3794_20908# VSUBS 0.00826f
C3185 m3_n3906_20908# VSUBS 0.02819f
C3186 m3_n3682_21020# VSUBS 0.02819f
C3187 m3_n3794_21020# VSUBS 0.00826f
C3188 m3_n3906_21020# VSUBS 0.02819f
C3189 m3_n3682_21132# VSUBS 0.02819f
C3190 m3_n3794_21132# VSUBS 0.00826f
C3191 m3_n3906_21132# VSUBS 0.02819f
C3192 m3_n3682_21244# VSUBS 0.02819f
C3193 m3_n3794_21244# VSUBS 0.00826f
C3194 m3_n3906_21244# VSUBS 0.02819f
C3195 m3_n3682_21356# VSUBS 0.02819f
C3196 m3_n3794_21356# VSUBS 0.00826f
C3197 m3_n3906_21356# VSUBS 0.02819f
C3198 m3_n3682_21468# VSUBS 0.02819f
C3199 m3_n3794_21468# VSUBS 0.00826f
C3200 m3_n3906_21468# VSUBS 0.02819f
C3201 m3_n3682_21580# VSUBS 0.02819f
C3202 m3_n3794_21580# VSUBS 0.00826f
C3203 m3_n3906_21580# VSUBS 0.02819f
C3204 m3_n3682_21692# VSUBS 0.02819f
C3205 m3_n3794_21692# VSUBS 0.00826f
C3206 m3_n3906_21692# VSUBS 0.02819f
C3207 m3_n3682_21804# VSUBS 0.02819f
C3208 m3_n3794_21804# VSUBS 0.00826f
C3209 m3_n3906_21804# VSUBS 0.02819f
C3210 m3_n3682_21916# VSUBS 0.02819f
C3211 m3_n3794_21916# VSUBS 0.00826f
C3212 m3_n3906_21916# VSUBS 0.02819f
C3213 m3_n3682_22028# VSUBS 0.02819f
C3214 m3_n3794_22028# VSUBS 0.00826f
C3215 m3_n3906_22028# VSUBS 0.02819f
C3216 m3_n3682_22140# VSUBS 0.02819f
C3217 m3_n3794_22140# VSUBS 0.00826f
C3218 m3_n3906_22140# VSUBS 0.02819f
C3219 m3_n3682_22252# VSUBS 0.02819f
C3220 m3_n3794_22252# VSUBS 0.00826f
C3221 m3_n3906_22252# VSUBS 0.02819f
C3222 m3_n3682_22364# VSUBS 0.02819f
C3223 m3_n3794_22364# VSUBS 0.00826f
C3224 m3_n3906_22364# VSUBS 0.02819f
C3225 m3_n3682_22476# VSUBS 0.02819f
C3226 m3_n3794_22476# VSUBS 0.00826f
C3227 m3_n3906_22476# VSUBS 0.02819f
C3228 m3_n3682_22588# VSUBS 0.02819f
C3229 m3_n3794_22588# VSUBS 0.00826f
C3230 m3_n3906_22588# VSUBS 0.02819f
C3231 m3_n3682_22700# VSUBS 0.02819f
C3232 m3_n3794_22700# VSUBS 0.00826f
C3233 m3_n3906_22700# VSUBS 0.02819f
C3234 m3_n3682_22812# VSUBS 0.02819f
C3235 m3_n3794_22812# VSUBS 0.00826f
C3236 m3_n3906_22812# VSUBS 0.02819f
C3237 m3_n3682_22924# VSUBS 0.04811f
C3238 m3_n3794_22924# VSUBS 0.02819f
C3239 m3_n3906_22924# VSUBS 0.04811f
C3240 pincelazo_0/m4_0_1537# VSUBS 0.06765f
C3241 x16/X VSUBS 0.94192f
C3242 x16/a_109_47# VSUBS 0.03269f
C3243 x15/X VSUBS 1.15081f
C3244 x15/a_109_47# VSUBS 0.03604f
C3245 x14/X VSUBS 0.7016f
C3246 x14/a_109_47# VSUBS 0.03605f
C3247 x4/A VSUBS 0.23978f
C3248 x13/X VSUBS 0.3987f
C3249 x13/a_109_47# VSUBS 0.0331f
C3250 x8/A VSUBS -1.14923f
C3251 x9/A VSUBS 0.31911f
C3252 m3_n3386_n6343# VSUBS -0.17199p
C3253 VDPWR VSUBS -19.59884f
C3254 x9/Y VSUBS -2.68025f
.ends

.subckt tt_um_tetrahedral_oscillator clk ena rst_n ua[0] ua[1] ua[2] ua[3] ua[4] ua[5]
+ ua[6] ua[7] ui_in[0] ui_in[1] ui_in[2] ui_in[3] ui_in[4] ui_in[5] ui_in[6] ui_in[7]
+ uio_in[0] uio_in[1] uio_in[2] uio_in[3] uio_in[4] uio_in[5] uio_in[6] uio_in[7]
+ uo_out[0] uo_out[1] uo_out[2] uo_out[3] VDPWR VGND
Xoscilador_base_0 VDPWR VDPWR VDPWR VDPWR VDPWR VDPWR VDPWR VDPWR VDPWR VDPWR VDPWR
+ VDPWR VDPWR VDPWR VDPWR VDPWR VDPWR VDPWR VDPWR VDPWR VDPWR VDPWR VDPWR VDPWR VDPWR
+ VDPWR VDPWR VDPWR VDPWR VDPWR VDPWR VDPWR VDPWR VDPWR VDPWR VDPWR VDPWR VDPWR VDPWR
+ VDPWR VDPWR VDPWR VDPWR VDPWR VDPWR VDPWR VDPWR VDPWR VDPWR VDPWR VDPWR VDPWR VDPWR
+ VDPWR VDPWR VDPWR VDPWR VDPWR VDPWR VDPWR VDPWR VDPWR VDPWR VDPWR VDPWR VDPWR VDPWR
+ VDPWR VDPWR VDPWR VDPWR VDPWR VDPWR VDPWR VDPWR VDPWR VDPWR VDPWR VDPWR VDPWR VDPWR
+ VDPWR VDPWR VDPWR VDPWR VDPWR VDPWR VDPWR VDPWR VDPWR VDPWR VDPWR VDPWR VDPWR VDPWR
+ VDPWR VDPWR VDPWR VDPWR VDPWR VDPWR VDPWR VDPWR VDPWR VDPWR VDPWR VDPWR VDPWR VDPWR
+ VDPWR VDPWR VDPWR VDPWR VDPWR VDPWR VDPWR VDPWR VDPWR VDPWR VDPWR VDPWR VDPWR VDPWR
+ VDPWR VDPWR VDPWR VDPWR VDPWR VDPWR VDPWR VDPWR VDPWR VDPWR VDPWR VDPWR VDPWR VDPWR
+ VDPWR VDPWR VDPWR VDPWR VDPWR VDPWR VDPWR VDPWR VDPWR VDPWR VDPWR VDPWR VDPWR VDPWR
+ VDPWR VDPWR VDPWR VDPWR VDPWR VDPWR VDPWR VDPWR VDPWR VDPWR VDPWR VDPWR VDPWR VDPWR
+ VDPWR VDPWR VDPWR VDPWR VDPWR VDPWR VDPWR VDPWR VDPWR VDPWR VDPWR VDPWR VDPWR VDPWR
+ VDPWR VDPWR VDPWR VDPWR VDPWR VDPWR VDPWR VDPWR VDPWR VDPWR VDPWR VDPWR VDPWR VDPWR
+ VDPWR VDPWR VDPWR VDPWR VDPWR VDPWR VDPWR VDPWR VDPWR VDPWR VDPWR VDPWR VDPWR VDPWR
+ VDPWR VDPWR VDPWR VDPWR VDPWR VDPWR VDPWR VDPWR VDPWR VDPWR VDPWR VDPWR VDPWR VDPWR
+ VDPWR VDPWR VDPWR VDPWR VDPWR VDPWR VDPWR VDPWR VDPWR VDPWR oscilador_base_0/semilogo_0/m4_0_0#
+ VDPWR VDPWR VDPWR VDPWR VDPWR VDPWR VDPWR VDPWR VDPWR VDPWR VDPWR VDPWR VDPWR VDPWR
+ VDPWR VDPWR VDPWR VDPWR VDPWR VDPWR VDPWR VDPWR VDPWR VDPWR VDPWR VDPWR VDPWR VDPWR
+ VDPWR VDPWR VDPWR VDPWR VDPWR VDPWR VDPWR VDPWR VDPWR VDPWR VDPWR VDPWR VDPWR VDPWR
+ VDPWR VDPWR VDPWR VDPWR VDPWR VDPWR VDPWR VDPWR VDPWR VDPWR VDPWR VDPWR VDPWR VDPWR
+ VDPWR VDPWR VDPWR VDPWR VDPWR VDPWR VDPWR VDPWR VDPWR VDPWR VDPWR VDPWR VDPWR VDPWR
+ VDPWR VDPWR VDPWR VDPWR VDPWR VDPWR VDPWR VDPWR VDPWR VDPWR VDPWR VDPWR VDPWR VDPWR
+ VDPWR VDPWR VDPWR VDPWR VDPWR VDPWR VDPWR VDPWR VDPWR VDPWR VDPWR VDPWR VDPWR VDPWR
+ VDPWR VDPWR VDPWR VDPWR VDPWR VDPWR VDPWR VDPWR VDPWR VDPWR VDPWR VDPWR VDPWR VDPWR
+ VDPWR VDPWR VDPWR VDPWR VDPWR VDPWR VDPWR VDPWR VDPWR VDPWR VDPWR VDPWR VDPWR VDPWR
+ VDPWR VDPWR VDPWR VDPWR VDPWR VDPWR VDPWR VDPWR VDPWR VDPWR VDPWR VDPWR VDPWR VDPWR
+ VDPWR VDPWR VDPWR VDPWR VDPWR VDPWR VDPWR VDPWR VDPWR VDPWR VDPWR VDPWR VDPWR VDPWR
+ VDPWR VDPWR VDPWR VDPWR VDPWR VDPWR VDPWR VDPWR VDPWR VDPWR VDPWR VDPWR VDPWR VDPWR
+ VDPWR VDPWR VDPWR VDPWR VDPWR VDPWR VDPWR VDPWR VDPWR VDPWR VDPWR VDPWR VDPWR VDPWR
+ VDPWR VDPWR VDPWR VDPWR VDPWR VDPWR VDPWR VDPWR VDPWR VDPWR VDPWR VDPWR VDPWR VDPWR
+ VDPWR VDPWR VDPWR VDPWR VDPWR VDPWR VDPWR VDPWR VDPWR VDPWR VDPWR VDPWR VDPWR VDPWR
+ VDPWR VDPWR VDPWR VDPWR VDPWR VDPWR VDPWR VDPWR VDPWR VDPWR VDPWR VDPWR VDPWR VDPWR
+ VDPWR VDPWR VDPWR VDPWR VDPWR VDPWR VDPWR VDPWR VDPWR VDPWR VDPWR VDPWR VDPWR VDPWR
+ VDPWR VDPWR VDPWR VDPWR VDPWR VDPWR VDPWR VDPWR VDPWR VDPWR VDPWR VDPWR VDPWR VDPWR
+ VDPWR VDPWR VDPWR VDPWR VDPWR VDPWR VDPWR VDPWR VDPWR VDPWR VDPWR VDPWR VDPWR VDPWR
+ VDPWR VDPWR VDPWR VDPWR VDPWR VDPWR VDPWR VDPWR VDPWR VDPWR VDPWR VDPWR VDPWR VDPWR
+ VDPWR VDPWR VDPWR VDPWR VDPWR VDPWR VDPWR VDPWR VDPWR VDPWR VDPWR VDPWR VDPWR VDPWR
+ VDPWR VDPWR VDPWR VDPWR VDPWR VDPWR VDPWR VDPWR VDPWR VDPWR VDPWR VDPWR VDPWR VDPWR
+ VDPWR VDPWR VDPWR VDPWR VDPWR VDPWR VDPWR VDPWR VDPWR VDPWR VDPWR VDPWR VDPWR VDPWR
+ VDPWR VDPWR VDPWR VDPWR VDPWR VDPWR VDPWR VDPWR VDPWR VDPWR VDPWR VDPWR VDPWR VDPWR
+ VDPWR VDPWR VDPWR VDPWR VDPWR VDPWR VDPWR VDPWR VDPWR VDPWR VDPWR VDPWR VDPWR VDPWR
+ VDPWR VDPWR VDPWR VDPWR VDPWR VDPWR VDPWR VDPWR VDPWR VDPWR VDPWR VDPWR VDPWR VDPWR
+ VDPWR VDPWR VDPWR VDPWR VDPWR VDPWR VDPWR VDPWR VDPWR VDPWR VDPWR VDPWR VDPWR VDPWR
+ VDPWR VDPWR VDPWR VDPWR VDPWR VDPWR VDPWR VDPWR VDPWR VDPWR VDPWR VDPWR VDPWR VDPWR
+ VDPWR VDPWR VDPWR VDPWR VDPWR VDPWR VDPWR VDPWR VDPWR VDPWR VDPWR VDPWR VDPWR VDPWR
+ VDPWR VDPWR VDPWR VDPWR VDPWR VDPWR VDPWR VDPWR VDPWR VDPWR VDPWR VDPWR VDPWR VDPWR
+ VDPWR VDPWR VDPWR VDPWR VDPWR VDPWR VDPWR VDPWR VDPWR VDPWR VDPWR VDPWR VDPWR VDPWR
+ VDPWR VDPWR VDPWR VDPWR VDPWR VDPWR VDPWR VDPWR VDPWR VDPWR VDPWR VDPWR VDPWR VDPWR
+ VDPWR VDPWR VDPWR VDPWR VDPWR VDPWR VDPWR VDPWR VDPWR VDPWR VDPWR VDPWR VDPWR VDPWR
+ VDPWR VDPWR VDPWR VDPWR VDPWR VDPWR VDPWR VDPWR VDPWR VDPWR VDPWR VDPWR VDPWR VDPWR
+ VDPWR VDPWR VDPWR VDPWR VDPWR VDPWR VDPWR VDPWR VDPWR VDPWR VDPWR VDPWR VDPWR VDPWR
+ VDPWR VDPWR VDPWR VDPWR VDPWR VDPWR VDPWR VDPWR VDPWR VDPWR VDPWR VDPWR VDPWR VDPWR
+ VDPWR VDPWR VDPWR VDPWR VDPWR VDPWR VDPWR VDPWR VDPWR VDPWR VDPWR VDPWR VDPWR VDPWR
+ VDPWR VDPWR VDPWR VDPWR VDPWR VDPWR VDPWR VDPWR VDPWR VDPWR VDPWR VDPWR VDPWR VDPWR
+ VDPWR VDPWR VDPWR VDPWR VDPWR VDPWR VDPWR VDPWR VDPWR VDPWR VDPWR VDPWR VDPWR VDPWR
+ VDPWR VDPWR VDPWR VDPWR VDPWR VDPWR VDPWR VDPWR VDPWR VDPWR VDPWR VDPWR VDPWR VDPWR
+ VDPWR VGND VDPWR VDPWR VDPWR VDPWR VDPWR uo_out[3] VDPWR VDPWR VDPWR VDPWR VDPWR
+ VDPWR VDPWR VDPWR VDPWR VDPWR VDPWR VDPWR VDPWR VDPWR VDPWR VDPWR VDPWR VDPWR VDPWR
+ VDPWR VDPWR VDPWR VDPWR VDPWR VDPWR VDPWR VDPWR VDPWR VDPWR VDPWR VDPWR VDPWR VDPWR
+ VDPWR VDPWR VDPWR VDPWR VDPWR VDPWR VDPWR VDPWR VDPWR VDPWR VDPWR VDPWR VDPWR VDPWR
+ VDPWR VDPWR VDPWR VDPWR VDPWR VDPWR VDPWR VDPWR VDPWR VDPWR VDPWR VDPWR VDPWR VDPWR
+ VDPWR VDPWR VDPWR VDPWR VDPWR VDPWR VDPWR VDPWR VDPWR VDPWR VDPWR VDPWR VDPWR VDPWR
+ VDPWR VDPWR VDPWR VDPWR VDPWR VDPWR VDPWR VDPWR VDPWR VDPWR VDPWR VDPWR VDPWR VDPWR
+ VDPWR VDPWR VDPWR VDPWR VDPWR VDPWR VDPWR VDPWR VDPWR VDPWR VDPWR VDPWR VDPWR VDPWR
+ VDPWR VDPWR VDPWR VDPWR VDPWR VDPWR VDPWR VDPWR VDPWR VDPWR VDPWR VDPWR VDPWR uo_out[1]
+ VDPWR VDPWR VDPWR VDPWR VDPWR VDPWR VDPWR VDPWR VDPWR VDPWR VDPWR VDPWR VDPWR VDPWR
+ VDPWR VDPWR VDPWR VDPWR VDPWR VDPWR VDPWR VDPWR VDPWR VDPWR VDPWR VDPWR VDPWR VDPWR
+ VDPWR VDPWR VDPWR VDPWR VDPWR VDPWR VDPWR VDPWR VDPWR VDPWR VDPWR VDPWR VDPWR VDPWR
+ VDPWR VDPWR VDPWR VDPWR VDPWR VDPWR VDPWR VDPWR VDPWR VDPWR VDPWR VDPWR VDPWR VDPWR
+ VDPWR VDPWR VDPWR VDPWR VDPWR VDPWR VDPWR VDPWR VDPWR VDPWR VDPWR VDPWR VDPWR VDPWR
+ VDPWR VDPWR VDPWR VDPWR VDPWR VDPWR VDPWR VDPWR VDPWR VDPWR VDPWR VDPWR VDPWR VDPWR
+ VDPWR VDPWR VDPWR VDPWR VDPWR VDPWR VDPWR VDPWR VDPWR VDPWR VDPWR VDPWR VDPWR VDPWR
+ VDPWR VDPWR VDPWR VDPWR VDPWR VDPWR VDPWR VDPWR VDPWR VDPWR VDPWR VDPWR VDPWR VDPWR
+ uo_out[0] VDPWR VDPWR VDPWR VDPWR VDPWR VDPWR VDPWR VDPWR VDPWR VDPWR VDPWR VDPWR
+ VDPWR VDPWR VDPWR VDPWR VDPWR VDPWR VDPWR VDPWR VDPWR VDPWR VDPWR VDPWR VDPWR VDPWR
+ VDPWR VDPWR VDPWR VDPWR VDPWR VDPWR VDPWR VDPWR VDPWR VDPWR VDPWR VDPWR VDPWR VDPWR
+ VDPWR VDPWR VDPWR VDPWR VDPWR VDPWR VDPWR VDPWR VDPWR VDPWR VDPWR VDPWR VDPWR VDPWR
+ VDPWR VDPWR VDPWR VDPWR VDPWR VDPWR VDPWR VDPWR VDPWR VDPWR VDPWR VDPWR VDPWR VDPWR
+ oscilador_base_0/x9/A VDPWR VDPWR VDPWR VDPWR VDPWR VDPWR VDPWR VDPWR VDPWR VDPWR
+ VDPWR VDPWR VDPWR VDPWR VDPWR VDPWR VDPWR VDPWR VDPWR VDPWR VDPWR VDPWR VDPWR VDPWR
+ VDPWR VDPWR VDPWR VDPWR VDPWR VDPWR uo_out[2] VDPWR VDPWR VDPWR VDPWR VDPWR VDPWR
+ VDPWR VDPWR VDPWR VDPWR VDPWR VDPWR VDPWR VDPWR VGND VDPWR VDPWR VDPWR VDPWR VDPWR
+ VDPWR VDPWR VDPWR VDPWR VDPWR VDPWR VDPWR VDPWR VDPWR VDPWR VDPWR oscilador_base
C0 ui_in[7] ui_in[6] 0.03102f
C1 uio_in[5] uo_out[0] 0.00438f
C2 oscilador_base_0/x9/Y oscilador_base_0/x9/A 0.11884f
C3 ena clk 0.03102f
C4 rst_n clk 0.03102f
C5 VDPWR uo_out[0] 0.06023f
C6 VDPWR oscilador_base_0/x9/A 3.408f
C7 oscilador_base_0/x8/A oscilador_base_0/x9/Y 0.8097f
C8 ui_in[1] ui_in[0] 0.03102f
C9 ui_in[4] ui_in[3] 0.03102f
C10 uio_in[3] uio_in[4] 0.03102f
C11 ui_in[2] ui_in[1] 0.03102f
C12 uio_in[2] uio_in[3] 0.03102f
C13 oscilador_base_0/x8/A VDPWR 4.50562f
C14 ua[3] oscilador_base_0/semilogo_0/m4_0_0# 0.01373f
C15 ui_in[5] ui_in[6] 0.03102f
C16 uio_in[5] uio_in[4] 0.03102f
C17 ui_in[7] uio_in[0] 0.03102f
C18 oscilador_base_0/x4/A oscilador_base_0/x9/Y 2.43594f
C19 uio_in[6] uio_in[7] 0.03102f
C20 oscilador_base_0/pincelazo_0/m4_0_1537# oscilador_base_0/pincelazo_0/m4_2662_1725# 0.51475f
C21 oscilador_base_0/x4/A VDPWR 4.25383f
C22 oscilador_base_0/semilogo_0/m4_0_0# ua[5] 0.01373f
C23 uo_out[2] uo_out[3] 0.03175f
C24 oscilador_base_0/x8/A oscilador_base_0/x9/A 2.00246f
C25 ua[4] oscilador_base_0/semilogo_0/m4_0_0# 0.01373f
C26 rst_n ui_in[0] 0.03102f
C27 uo_out[1] uo_out[2] 0.03171f
C28 ua[6] oscilador_base_0/semilogo_0/m4_0_0# 0.01373f
C29 uo_out[1] uo_out[3] -0
C30 oscilador_base_0/pincelazo_0/m4_3975_2025# oscilador_base_0/pincelazo_0/m4_3975_1537# 0.13385f
C31 uio_in[5] uio_in[6] 0.03102f
C32 oscilador_base_0/pincelazo_0/m4_3975_2025# oscilador_base_0/pincelazo_0/m4_0_1537# 0.34686f
C33 oscilador_base_0/semilogo_0/m4_0_0# ua[2] 0.01373f
C34 uo_out[2] VDPWR 0.059f
C35 ui_in[5] ui_in[4] 0.03102f
C36 uo_out[3] VDPWR 0.06138f
C37 oscilador_base_0/x4/A oscilador_base_0/x9/A 0.02281f
C38 uo_out[1] VDPWR 0.05937f
C39 VDPWR oscilador_base_0/x9/Y 3.07888f
C40 uio_in[7] uo_out[0] 0.0354f
C41 oscilador_base_0/pincelazo_0/m4_0_1537# oscilador_base_0/pincelazo_0/m4_3975_1537# 0.42808f
C42 oscilador_base_0/x8/A oscilador_base_0/x4/A 0.16239f
C43 ui_in[2] ui_in[3] 0.03102f
C44 uio_in[2] uio_in[1] 0.03102f
C45 uio_in[6] uo_out[0] 0.00438f
C46 uo_out[1] uo_out[0] 0.03191f
C47 uio_in[1] uio_in[0] 0.03102f
C48 ua[0] VGND 0.14696f
C49 ua[1] VGND 0.14696f
C50 ua[2] VGND 0.14696f
C51 ua[3] VGND 0.14696f
C52 ua[4] VGND 0.14696f
C53 ua[5] VGND 0.14696f
C54 ua[6] VGND 0.14696f
C55 ua[7] VGND 0.14696f
C56 ena VGND 0.07038f
C57 clk VGND 0.04288f
C58 rst_n VGND 0.04288f
C59 ui_in[0] VGND 0.04288f
C60 ui_in[1] VGND 0.04288f
C61 ui_in[2] VGND 0.04288f
C62 ui_in[3] VGND 0.04288f
C63 ui_in[4] VGND 0.04288f
C64 ui_in[5] VGND 0.04288f
C65 ui_in[6] VGND 0.04288f
C66 ui_in[7] VGND 0.04288f
C67 uio_in[0] VGND 0.04288f
C68 uio_in[1] VGND 0.04288f
C69 uio_in[2] VGND 0.04288f
C70 uio_in[3] VGND 0.04288f
C71 uio_in[4] VGND 0.04288f
C72 uio_in[5] VGND 0.03748f
C73 uio_in[6] VGND 0.03748f
C74 uio_in[7] VGND 0.03748f
C75 VDPWR VGND 0.59246f
C76 uo_out[3] VGND -1.15633f
C77 uo_out[0] VGND -0.19229f
C78 uo_out[2] VGND -3.61648f
C79 oscilador_base_0/x4/A VGND -8.00687f
C80 uo_out[1] VGND -0.17705f
C81 oscilador_base_0/x8/A VGND -4.10629f
C82 oscilador_base_0/x9/A VGND -0.09754f
C83 oscilador_base_0/x9/Y VGND -6.88454f
.ends
