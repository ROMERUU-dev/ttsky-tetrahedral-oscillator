** sch_path: /home/romeruu/pdk/sky130A/libs.tech/xschem/lvs_top.sch

.include /home/romeruu/pdk/sky130A/libs.ref/sky130_fd_sc_hd/spice/sky130_fd_sc_hd.spice

**.subckt lvs_top VGND VDPWR
*.iopin VGND
*.iopin VDPWR
x1 VGND VDPWR tt_um_tetrahedral_oscilator_xschem_lvs
**.ends

* expanding   symbol:
*+  /home/romeruu/tt_um_tetrahedral-oscilator/xschem/tt_um_tetrahedral_oscilator_xschem_lvs.sym # of pins=2
** sym_path: /home/romeruu/tt_um_tetrahedral-oscilator/xschem/tt_um_tetrahedral_oscilator_xschem_lvs.sym
** sch_path: /home/romeruu/tt_um_tetrahedral-oscilator/xschem/tt_um_tetrahedral_oscilator_xschem_lvs.sch
.subckt tt_um_tetrahedral_oscilator_xschem_lvs VGND VDPWR
*.iopin VGND
*.iopin VDPWR
x1 net1 VGND VGND VDPWR VDPWR net2 sky130_fd_sc_hd__inv_1
x2 net1 VGND VGND VDPWR VDPWR net2 sky130_fd_sc_hd__inv_2
x3 net2 VGND VGND VDPWR VDPWR net1 sky130_fd_sc_hd__inv_2
x4 net2 VGND VGND VDPWR VDPWR net1 sky130_fd_sc_hd__inv_1
x5 net3 VGND VGND VDPWR VDPWR net4 sky130_fd_sc_hd__inv_1
x6 net3 VGND VGND VDPWR VDPWR net4 sky130_fd_sc_hd__inv_2
x7 net4 VGND VGND VDPWR VDPWR net3 sky130_fd_sc_hd__inv_2
x8 net4 VGND VGND VDPWR VDPWR net3 sky130_fd_sc_hd__inv_1
x9 net3 VGND VGND VDPWR VDPWR net1 sky130_fd_sc_hd__inv_4
x10 net1 VGND VGND VDPWR VDPWR net4 sky130_fd_sc_hd__inv_4
x11 net4 VGND VGND VDPWR VDPWR net2 sky130_fd_sc_hd__inv_4
x12 net2 VGND VGND VDPWR VDPWR net3 sky130_fd_sc_hd__inv_4
x13 net1 VGND VGND VDPWR VDPWR net5 sky130_fd_sc_hd__buf_16
x14 net3 VGND VGND VDPWR VDPWR net6 sky130_fd_sc_hd__buf_16
x15 net2 VGND VGND VDPWR VDPWR net7 sky130_fd_sc_hd__buf_16
x16 net4 VGND VGND VDPWR VDPWR net8 sky130_fd_sc_hd__buf_16
XC1 net1 VGND sky130_fd_pr__cap_mim_m3_1 W=30 L=30 MF=1 m=1
XC2 net2 VGND sky130_fd_pr__cap_mim_m3_1 W=30 L=30 MF=1 m=1
XC3 net3 VGND sky130_fd_pr__cap_mim_m3_1 W=30 L=30 MF=1 m=1
XC4 net4 VGND sky130_fd_pr__cap_mim_m3_1 W=30 L=30 MF=1 m=1
XC5 net1 VGND sky130_fd_pr__cap_mim_m3_1 W=30 L=30 MF=1 m=1
XC6 net1 VGND sky130_fd_pr__cap_mim_m3_1 W=30 L=30 MF=1 m=1
XC7 net1 VGND sky130_fd_pr__cap_mim_m3_1 W=30 L=30 MF=1 m=1
XC8 net2 VGND sky130_fd_pr__cap_mim_m3_1 W=30 L=30 MF=1 m=1
XC9 net2 VGND sky130_fd_pr__cap_mim_m3_1 W=30 L=30 MF=1 m=1
XC10 net2 VGND sky130_fd_pr__cap_mim_m3_1 W=30 L=30 MF=1 m=1
XC11 net3 VGND sky130_fd_pr__cap_mim_m3_1 W=30 L=30 MF=1 m=1
XC12 net3 VGND sky130_fd_pr__cap_mim_m3_1 W=30 L=30 MF=1 m=1
XC13 net3 VGND sky130_fd_pr__cap_mim_m3_1 W=30 L=30 MF=1 m=1
XC14 net4 VGND sky130_fd_pr__cap_mim_m3_1 W=30 L=30 MF=1 m=1
XC15 net4 VGND sky130_fd_pr__cap_mim_m3_1 W=30 L=30 MF=1 m=1
XC16 net4 VGND sky130_fd_pr__cap_mim_m3_1 W=30 L=30 MF=1 m=1
.ends

.GLOBAL VGND
.end
