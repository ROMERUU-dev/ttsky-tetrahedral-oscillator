* Testbench inicial para tt_um_tetrahedral_oscilator
.lib /home/romeruu/pdk/sky130A/libs.tech/combined/sky130.lib.spice tt
.include ../spice/tt_um_tetrahedral_oscilator.spice
Vvdpwr VDPWR 0 1.8
Vvgnd VGND 0 0
Xdut VGND VDPWR tt_um_tetrahedral_oscilator
.save all
.tran 1n 1u
.print tran v(VDPWR)
.end
